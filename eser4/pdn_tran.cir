* ============================================================================
* Transient analysis of the PDN with the supplied die current load (no decaps)
* Voltage at the die interface: V(vdie). Run from the SW2_STM root folder.
* The PWL load lasts 12 us (72 ps steps): simulate one pass of the waveform.
* ============================================================================
.include "../eser1/pdn.cir"

* keep only the node of interest (avoids storing ~900 nodes x 166k time points)
.save V(vdie)

.tran 72p 12u 0 72p
.meas tran vpp PP V(vdie)
.meas tran vmin MIN V(vdie)
.meas tran vmax MAX V(vdie)
.meas tran vpp_ss PP V(vdie) FROM=0.5u TO=12u
.end
