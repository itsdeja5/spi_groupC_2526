* ============================================================================
* AC analysis: PDN impedance seen from the die interface port (no decaps)
* Z(f) = V(vdie) / 1 A, since a 1 A AC test current is injected at vdie.
* The VRM source is a short circuit for AC; the die PWL current load is
* ignored in AC (no AC magnitude).
* ============================================================================
.include "../eser1/pdn.cir"

* AC test current into the die node (the "Port1" of the slide schematic)
Iac 0 vdie DC 0 AC 1

.ac dec 1000 1 5G
.meas ac zmax MAX mag(V(vdie))
.meas ac fpk  WHEN mag(V(vdie))=zmax
.meas ac z100M FIND mag(V(vdie)) at 100Meg
.end
