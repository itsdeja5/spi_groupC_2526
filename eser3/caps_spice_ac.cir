* ============================================================================
* Stand-alone impedance of the vendor SPICE capacitor models
* Each capacitor gets its own 1 A AC test current into port1, with port2 tied
* to ground (the same way the parts are connected in the PDN):
*   V(zXXX) = Z(f) of the part with code XXX.
* Place this file in the SW2_STM root folder.
* ============================================================================
.include "../input_files/capacitors/GCM033R71A103KA03.mod"
.include "../input_files/capacitors/GCM033R71A682KA03.mod"
.include "../input_files/capacitors/GCM033R71A472KA03.mod"
.include "../input_files/capacitors/GCM033R71A332KA03.mod"
.include "../input_files/capacitors/GCM033R71A222KA03.mod"
.include "../input_files/capacitors/GCM033R71A152KA03.mod"

* 10 nF
I103 0 z103 DC 0 AC 1
X103 z103 0 GCM033R71A103KA03
* 6.8 nF
I682 0 z682 DC 0 AC 1
X682 z682 0 GCM033R71A682KA03
* 4.7 nF
I472 0 z472 DC 0 AC 1
X472 z472 0 GCM033R71A472KA03
* 3.3 nF
I332 0 z332 DC 0 AC 1
X332 z332 0 GCM033R71A332KA03
* 2.2 nF
I222 0 z222 DC 0 AC 1
X222 z222 0 GCM033R71A222KA03
* 1.5 nF
I152 0 z152 DC 0 AC 1
X152 z152 0 GCM033R71A152KA03

.ac dec 500 100 6G
.end
