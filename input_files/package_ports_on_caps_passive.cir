**********************************************************
** STATE-SPACE REALIZATION
** IN SPICE LANGUAGE
** This file is automatically generated
**********************************************************
** Created: 20-May-2023 by IdEM MP 12 (12.3.0)
**********************************************************
**
**********************************************************
** COMMENTS
**********************************************************
**
**  Modal data exported
**  Port[1] = VDD_C01_1
**  Port[2] = VDD_C02_1
**  Port[3] = VDD_C03_1
**  Port[4] = VDD_C04_1
**  Port[5] = VDD_C05_1
**  Port[6] = board
**  Port[7] = die
**
**********************************************************
**
**
**---------------------------
** Options Used in IdEM Flow
**---------------------------
**
** Fitting Options **
**
** Bandwidth: 1.0000e+10 Hz
** Order: [4 2 20]
** SplitType: none
** tol: 1.0000e-04
** DC Point: enforced
** Weights: relative
**    Alpha: 0.5
**    RelThreshold: 1e-10
**
**---------------------------
**
** Passivity Options **
**
** Alg: SOC+HAM
**    Max SOC it: 50
**    Max HAM it: 50
** Freq sampling: manual
**    In-band samples: 200
**    Off-band samples: 100
** DC Point: enforced
** Optimization method: Data based
** Weights: relative
**    Alpha: 0.5
**    Relative threshold: 1e-10
**
**---------------------------
**
** Netlist Options **
**
** Netlist format: SPICE standard
** Port reference: separate (floating)
** Resistor synthesis: standard
**
**---------------------------
**
**********************************************************
* NOTE:
* a_i  --> input node associated to the port i
* b_i  --> reference node associated to the port i
**********************************************************

***********************************
* Interface (ports specification) *
***********************************
.subckt package_ports_on_caps_passive
+  a_1 b_1
+  a_2 b_2
+  a_3 b_3
+  a_4 b_4
+  a_5 b_5
+  a_6 b_6
+  a_7 b_7
***********************************

******************************************
* Main circuit connected to output nodes *
******************************************

* Port 1
VI_1 a_1 NI_1 0
RI_1 NI_1 b_1 1.0000000000000001e-01
GC_1_1 b_1 NI_1 NS_1 0 2.1016324737306369e-01
GC_1_2 b_1 NI_1 NS_2 0 -1.7073104094741305e-04
GC_1_3 b_1 NI_1 NS_3 0 -2.8177160834291048e-03
GC_1_4 b_1 NI_1 NS_4 0 -6.5585238012808222e-03
GC_1_5 b_1 NI_1 NS_5 0 -2.2131969291711183e-03
GC_1_6 b_1 NI_1 NS_6 0 2.3181182273347962e-06
GC_1_7 b_1 NI_1 NS_7 0 -3.9678560911744759e-06
GC_1_8 b_1 NI_1 NS_8 0 -2.0614242647610678e-06
GC_1_9 b_1 NI_1 NS_9 0 -9.0939891133249716e-05
GC_1_10 b_1 NI_1 NS_10 0 -6.1465719361921398e-05
GC_1_11 b_1 NI_1 NS_11 0 -3.2250801450919148e-04
GC_1_12 b_1 NI_1 NS_12 0 1.9202687829938470e-05
GC_1_13 b_1 NI_1 NS_13 0 -6.2785589548613140e-04
GC_1_14 b_1 NI_1 NS_14 0 1.0867969006535971e-04
GC_1_15 b_1 NI_1 NS_15 0 -4.9782498153391293e-07
GC_1_16 b_1 NI_1 NS_16 0 2.1023085651030808e-06
GC_1_17 b_1 NI_1 NS_17 0 2.8242242927944848e-05
GC_1_18 b_1 NI_1 NS_18 0 -2.8548704423724567e-05
GC_1_19 b_1 NI_1 NS_19 0 -7.2343842003433497e-07
GC_1_20 b_1 NI_1 NS_20 0 1.7919835642167022e-06
GC_1_21 b_1 NI_1 NS_21 0 1.6202751198358099e-03
GC_1_22 b_1 NI_1 NS_22 0 -4.4308166953758019e-05
GC_1_23 b_1 NI_1 NS_23 0 -1.1424295304298764e-03
GC_1_24 b_1 NI_1 NS_24 0 7.8836610255539328e-05
GC_1_25 b_1 NI_1 NS_25 0 1.1999347124922481e-03
GC_1_26 b_1 NI_1 NS_26 0 -3.1617127581501793e-05
GC_1_27 b_1 NI_1 NS_27 0 1.6518009625533534e-06
GC_1_28 b_1 NI_1 NS_28 0 7.6550758774207512e-06
GC_1_29 b_1 NI_1 NS_29 0 -4.5819547323185691e-05
GC_1_30 b_1 NI_1 NS_30 0 -9.8203868378256755e-06
GC_1_31 b_1 NI_1 NS_31 0 2.7967366394091091e-04
GC_1_32 b_1 NI_1 NS_32 0 -4.1660994946899980e-06
GC_1_33 b_1 NI_1 NS_33 0 -2.7259166207842716e-04
GC_1_34 b_1 NI_1 NS_34 0 9.2660131310493726e-05
GC_1_35 b_1 NI_1 NS_35 0 5.8655941465404991e-07
GC_1_36 b_1 NI_1 NS_36 0 1.0901652159393740e-06
GC_1_37 b_1 NI_1 NS_37 0 -2.0040317844724547e-05
GC_1_38 b_1 NI_1 NS_38 0 -3.3640194347535999e-05
GC_1_39 b_1 NI_1 NS_39 0 -5.1434278188698711e-06
GC_1_40 b_1 NI_1 NS_40 0 -2.5248210921223795e-06
GC_1_41 b_1 NI_1 NS_41 0 2.0993119746563925e-03
GC_1_42 b_1 NI_1 NS_42 0 -5.5237820687202644e-05
GC_1_43 b_1 NI_1 NS_43 0 -1.6619384502591403e-03
GC_1_44 b_1 NI_1 NS_44 0 9.8763019639900424e-04
GC_1_45 b_1 NI_1 NS_45 0 8.8425286146662631e-04
GC_1_46 b_1 NI_1 NS_46 0 -6.5189585133351767e-05
GC_1_47 b_1 NI_1 NS_47 0 -1.3180229680516382e-05
GC_1_48 b_1 NI_1 NS_48 0 3.1640056783579726e-05
GC_1_49 b_1 NI_1 NS_49 0 -6.8325383063411890e-05
GC_1_50 b_1 NI_1 NS_50 0 -1.1023644473924847e-05
GC_1_51 b_1 NI_1 NS_51 0 3.2564265633377358e-04
GC_1_52 b_1 NI_1 NS_52 0 -8.0259375644896376e-06
GC_1_53 b_1 NI_1 NS_53 0 -2.8205453757711749e-04
GC_1_54 b_1 NI_1 NS_54 0 1.2011518389438507e-04
GC_1_55 b_1 NI_1 NS_55 0 7.3813743092115046e-07
GC_1_56 b_1 NI_1 NS_56 0 1.1108987803710151e-06
GC_1_57 b_1 NI_1 NS_57 0 -6.6150088084783278e-05
GC_1_58 b_1 NI_1 NS_58 0 -5.5266733241980461e-05
GC_1_59 b_1 NI_1 NS_59 0 -2.3158721261771879e-06
GC_1_60 b_1 NI_1 NS_60 0 -2.0700340374299825e-06
GC_1_61 b_1 NI_1 NS_61 0 -1.4913895408655582e-03
GC_1_62 b_1 NI_1 NS_62 0 -4.0461957749438362e-05
GC_1_63 b_1 NI_1 NS_63 0 -1.1967740035625566e-03
GC_1_64 b_1 NI_1 NS_64 0 2.3028994823810547e-04
GC_1_65 b_1 NI_1 NS_65 0 1.2897461833720797e-03
GC_1_66 b_1 NI_1 NS_66 0 -9.8721277932726711e-05
GC_1_67 b_1 NI_1 NS_67 0 -1.4919189089158637e-05
GC_1_68 b_1 NI_1 NS_68 0 4.1289973607895508e-05
GC_1_69 b_1 NI_1 NS_69 0 4.1296346406406373e-05
GC_1_70 b_1 NI_1 NS_70 0 -2.2385971401784570e-06
GC_1_71 b_1 NI_1 NS_71 0 1.6884017207407045e-04
GC_1_72 b_1 NI_1 NS_72 0 7.2072646018814566e-06
GC_1_73 b_1 NI_1 NS_73 0 -3.6706430634635926e-04
GC_1_74 b_1 NI_1 NS_74 0 7.7032411520676860e-05
GC_1_75 b_1 NI_1 NS_75 0 2.4507787381590992e-07
GC_1_76 b_1 NI_1 NS_76 0 1.7196529262923273e-06
GC_1_77 b_1 NI_1 NS_77 0 -5.7118862202810746e-05
GC_1_78 b_1 NI_1 NS_78 0 -9.1636568789026608e-05
GC_1_79 b_1 NI_1 NS_79 0 -1.3130974631670371e-05
GC_1_80 b_1 NI_1 NS_80 0 -1.9091989452798374e-06
GC_1_81 b_1 NI_1 NS_81 0 1.6826022122433174e-02
GC_1_82 b_1 NI_1 NS_82 0 -3.5019067994772218e-05
GC_1_83 b_1 NI_1 NS_83 0 -1.0519884569861011e-03
GC_1_84 b_1 NI_1 NS_84 0 1.0237325246280928e-03
GC_1_85 b_1 NI_1 NS_85 0 9.8433488057727333e-04
GC_1_86 b_1 NI_1 NS_86 0 -1.1444482683898872e-04
GC_1_87 b_1 NI_1 NS_87 0 -2.5564736064395268e-05
GC_1_88 b_1 NI_1 NS_88 0 5.3204477640887909e-05
GC_1_89 b_1 NI_1 NS_89 0 -6.9030308959221225e-05
GC_1_90 b_1 NI_1 NS_90 0 -6.5930410542319848e-06
GC_1_91 b_1 NI_1 NS_91 0 -1.5940879856386129e-04
GC_1_92 b_1 NI_1 NS_92 0 6.1015920200245263e-06
GC_1_93 b_1 NI_1 NS_93 0 -2.4452462846571152e-04
GC_1_94 b_1 NI_1 NS_94 0 6.4432296002682661e-05
GC_1_95 b_1 NI_1 NS_95 0 -5.1094850598126288e-08
GC_1_96 b_1 NI_1 NS_96 0 1.4406663861484951e-06
GC_1_97 b_1 NI_1 NS_97 0 -9.9863741645719571e-05
GC_1_98 b_1 NI_1 NS_98 0 -9.5115042664237391e-05
GC_1_99 b_1 NI_1 NS_99 0 -1.1053292579860759e-05
GC_1_100 b_1 NI_1 NS_100 0 5.8356197776385533e-06
GC_1_101 b_1 NI_1 NS_101 0 6.5042636224139277e-02
GC_1_102 b_1 NI_1 NS_102 0 5.4946027244558572e-04
GC_1_103 b_1 NI_1 NS_103 0 1.0300356406854951e-02
GC_1_104 b_1 NI_1 NS_104 0 4.5278315904991664e-06
GC_1_105 b_1 NI_1 NS_105 0 -4.4679043910123581e-04
GC_1_106 b_1 NI_1 NS_106 0 -1.0600045573846383e-05
GC_1_107 b_1 NI_1 NS_107 0 -4.7071145524683741e-06
GC_1_108 b_1 NI_1 NS_108 0 8.7547622446845545e-06
GC_1_109 b_1 NI_1 NS_109 0 -1.5225651951166859e-03
GC_1_110 b_1 NI_1 NS_110 0 -5.0105361245458705e-04
GC_1_111 b_1 NI_1 NS_111 0 1.1939376044745880e-03
GC_1_112 b_1 NI_1 NS_112 0 3.1798127644716811e-04
GC_1_113 b_1 NI_1 NS_113 0 -1.0336155168954482e-02
GC_1_114 b_1 NI_1 NS_114 0 5.3486215898866673e-04
GC_1_115 b_1 NI_1 NS_115 0 -7.2515478702338389e-06
GC_1_116 b_1 NI_1 NS_116 0 5.0608992420712003e-05
GC_1_117 b_1 NI_1 NS_117 0 5.5316440494803323e-05
GC_1_118 b_1 NI_1 NS_118 0 -1.1600763263878479e-05
GC_1_119 b_1 NI_1 NS_119 0 -9.4275319764900364e-06
GC_1_120 b_1 NI_1 NS_120 0 -1.2124178784777161e-06
GC_1_121 b_1 NI_1 NS_121 0 1.9029178770755464e-02
GC_1_122 b_1 NI_1 NS_122 0 -1.5385231283857111e-04
GC_1_123 b_1 NI_1 NS_123 0 -2.3606469579520624e-03
GC_1_124 b_1 NI_1 NS_124 0 4.2389355133429498e-03
GC_1_125 b_1 NI_1 NS_125 0 -1.6791595810681027e-03
GC_1_126 b_1 NI_1 NS_126 0 2.9148110524437334e-04
GC_1_127 b_1 NI_1 NS_127 0 5.4038389144946789e-05
GC_1_128 b_1 NI_1 NS_128 0 -1.2566566091513201e-04
GC_1_129 b_1 NI_1 NS_129 0 3.0013520579206237e-05
GC_1_130 b_1 NI_1 NS_130 0 6.6197448831396941e-06
GC_1_131 b_1 NI_1 NS_131 0 4.1607730819360835e-05
GC_1_132 b_1 NI_1 NS_132 0 1.1075871214363996e-05
GC_1_133 b_1 NI_1 NS_133 0 -5.6473698902611571e-04
GC_1_134 b_1 NI_1 NS_134 0 1.3264079027705493e-04
GC_1_135 b_1 NI_1 NS_135 0 -6.3715107037904091e-06
GC_1_136 b_1 NI_1 NS_136 0 9.2905962521683469e-06
GC_1_137 b_1 NI_1 NS_137 0 1.6208918975322279e-04
GC_1_138 b_1 NI_1 NS_138 0 2.9037983350355069e-04
GC_1_139 b_1 NI_1 NS_139 0 3.8814645053087501e-05
GC_1_140 b_1 NI_1 NS_140 0 -1.6037705359613934e-06
GD_1_1 b_1 NI_1 NA_1 0 6.1874782437474511e+00
GD_1_2 b_1 NI_1 NA_2 0 -9.8975389470257300e-04
GD_1_3 b_1 NI_1 NA_3 0 -1.3130924649199936e-03
GD_1_4 b_1 NI_1 NA_4 0 1.0045987827434918e-03
GD_1_5 b_1 NI_1 NA_5 0 -1.0796798789852773e-02
GD_1_6 b_1 NI_1 NA_6 0 -4.0477523691983291e-02
GD_1_7 b_1 NI_1 NA_7 0 -1.1803018808171289e-02
*
* Port 2
VI_2 a_2 NI_2 0
RI_2 NI_2 b_2 1.0000000000000001e-01
GC_2_1 b_2 NI_2 NS_1 0 1.6202751198358099e-03
GC_2_2 b_2 NI_2 NS_2 0 -4.4308166953758019e-05
GC_2_3 b_2 NI_2 NS_3 0 -1.1424295304298764e-03
GC_2_4 b_2 NI_2 NS_4 0 7.8836610255539328e-05
GC_2_5 b_2 NI_2 NS_5 0 1.1999347124922481e-03
GC_2_6 b_2 NI_2 NS_6 0 -3.1617127581501793e-05
GC_2_7 b_2 NI_2 NS_7 0 1.6518009625533534e-06
GC_2_8 b_2 NI_2 NS_8 0 7.6550758774207512e-06
GC_2_9 b_2 NI_2 NS_9 0 -4.5819547323185691e-05
GC_2_10 b_2 NI_2 NS_10 0 -9.8203868378256755e-06
GC_2_11 b_2 NI_2 NS_11 0 2.7967366394091091e-04
GC_2_12 b_2 NI_2 NS_12 0 -4.1660994946899980e-06
GC_2_13 b_2 NI_2 NS_13 0 -2.7259166207842716e-04
GC_2_14 b_2 NI_2 NS_14 0 9.2660131310493726e-05
GC_2_15 b_2 NI_2 NS_15 0 5.8655941465404991e-07
GC_2_16 b_2 NI_2 NS_16 0 1.0901652159393740e-06
GC_2_17 b_2 NI_2 NS_17 0 -2.0040317844724547e-05
GC_2_18 b_2 NI_2 NS_18 0 -3.3640194347535999e-05
GC_2_19 b_2 NI_2 NS_19 0 -5.1434278188698711e-06
GC_2_20 b_2 NI_2 NS_20 0 -2.5248210921223795e-06
GC_2_21 b_2 NI_2 NS_21 0 2.6781268159156946e-01
GC_2_22 b_2 NI_2 NS_22 0 -1.0093564164551124e-04
GC_2_23 b_2 NI_2 NS_23 0 -7.8004702612452959e-04
GC_2_24 b_2 NI_2 NS_24 0 -2.7873696050983113e-03
GC_2_25 b_2 NI_2 NS_25 0 -4.2976484194726054e-03
GC_2_26 b_2 NI_2 NS_26 0 -9.0072897474639216e-05
GC_2_27 b_2 NI_2 NS_27 0 -5.7883420359771061e-05
GC_2_28 b_2 NI_2 NS_28 0 7.6682785050228392e-05
GC_2_29 b_2 NI_2 NS_29 0 -3.6461427912039294e-05
GC_2_30 b_2 NI_2 NS_30 0 -3.3927317761838227e-05
GC_2_31 b_2 NI_2 NS_31 0 -2.3881056666933594e-04
GC_2_32 b_2 NI_2 NS_32 0 -8.3881942998332553e-06
GC_2_33 b_2 NI_2 NS_33 0 -9.9095974938780978e-05
GC_2_34 b_2 NI_2 NS_34 0 5.9778748969263165e-05
GC_2_35 b_2 NI_2 NS_35 0 7.4222575609536247e-07
GC_2_36 b_2 NI_2 NS_36 0 -9.1551304501006122e-07
GC_2_37 b_2 NI_2 NS_37 0 -4.9485271961888419e-06
GC_2_38 b_2 NI_2 NS_38 0 -1.9537081851446776e-05
GC_2_39 b_2 NI_2 NS_39 0 -9.7140077274221776e-06
GC_2_40 b_2 NI_2 NS_40 0 3.0381559514401157e-07
GC_2_41 b_2 NI_2 NS_41 0 5.6347892964396948e-02
GC_2_42 b_2 NI_2 NS_42 0 -1.4900616059080048e-05
GC_2_43 b_2 NI_2 NS_43 0 -7.3288038252399988e-04
GC_2_44 b_2 NI_2 NS_44 0 2.3338574616378993e-03
GC_2_45 b_2 NI_2 NS_45 0 3.0684908481573792e-04
GC_2_46 b_2 NI_2 NS_46 0 -1.5488867288087385e-04
GC_2_47 b_2 NI_2 NS_47 0 -3.5922212188747759e-05
GC_2_48 b_2 NI_2 NS_48 0 7.5413185425090570e-05
GC_2_49 b_2 NI_2 NS_49 0 -4.8653481441043475e-05
GC_2_50 b_2 NI_2 NS_50 0 -1.4226397979187680e-05
GC_2_51 b_2 NI_2 NS_51 0 -2.8035085498310716e-04
GC_2_52 b_2 NI_2 NS_52 0 -6.9530662361558950e-06
GC_2_53 b_2 NI_2 NS_53 0 -1.1456303889652044e-04
GC_2_54 b_2 NI_2 NS_54 0 7.0538732978819629e-05
GC_2_55 b_2 NI_2 NS_55 0 4.0634106041341693e-07
GC_2_56 b_2 NI_2 NS_56 0 2.1343013163205424e-07
GC_2_57 b_2 NI_2 NS_57 0 -1.2746069161574696e-04
GC_2_58 b_2 NI_2 NS_58 0 -1.0348890250911312e-04
GC_2_59 b_2 NI_2 NS_59 0 -1.5078100461757235e-05
GC_2_60 b_2 NI_2 NS_60 0 3.7050522811317754e-06
GC_2_61 b_2 NI_2 NS_61 0 1.6711071476495854e-02
GC_2_62 b_2 NI_2 NS_62 0 -2.2390160693020319e-05
GC_2_63 b_2 NI_2 NS_63 0 -5.5471271208772717e-04
GC_2_64 b_2 NI_2 NS_64 0 -6.9413842415296328e-05
GC_2_65 b_2 NI_2 NS_65 0 1.1005601442115290e-03
GC_2_66 b_2 NI_2 NS_66 0 4.8889132446521170e-05
GC_2_67 b_2 NI_2 NS_67 0 1.7186181829475448e-05
GC_2_68 b_2 NI_2 NS_68 0 -3.0115273539780672e-05
GC_2_69 b_2 NI_2 NS_69 0 2.4705118794096391e-05
GC_2_70 b_2 NI_2 NS_70 0 -1.0844485082696160e-06
GC_2_71 b_2 NI_2 NS_71 0 -1.4488176994124349e-04
GC_2_72 b_2 NI_2 NS_72 0 -1.3368685093386784e-05
GC_2_73 b_2 NI_2 NS_73 0 -1.5420366508208790e-04
GC_2_74 b_2 NI_2 NS_74 0 5.7376031599230300e-05
GC_2_75 b_2 NI_2 NS_75 0 3.6416844424736076e-07
GC_2_76 b_2 NI_2 NS_76 0 4.5211340710745911e-07
GC_2_77 b_2 NI_2 NS_77 0 -4.3594671079703852e-06
GC_2_78 b_2 NI_2 NS_78 0 4.8276509901633825e-05
GC_2_79 b_2 NI_2 NS_79 0 8.4619189024792144e-06
GC_2_80 b_2 NI_2 NS_80 0 -8.6764392940775011e-08
GC_2_81 b_2 NI_2 NS_81 0 2.8536263718977246e-03
GC_2_82 b_2 NI_2 NS_82 0 -2.8217694109996332e-05
GC_2_83 b_2 NI_2 NS_83 0 -4.8606322974587701e-04
GC_2_84 b_2 NI_2 NS_84 0 -4.2182228873843461e-04
GC_2_85 b_2 NI_2 NS_85 0 5.5160903990095916e-04
GC_2_86 b_2 NI_2 NS_86 0 2.4115001380388705e-04
GC_2_87 b_2 NI_2 NS_87 0 7.3975545741972916e-05
GC_2_88 b_2 NI_2 NS_88 0 -1.3702751418197162e-04
GC_2_89 b_2 NI_2 NS_89 0 -4.3215523290993496e-05
GC_2_90 b_2 NI_2 NS_90 0 -4.6651573168444194e-06
GC_2_91 b_2 NI_2 NS_91 0 1.3733887935975852e-04
GC_2_92 b_2 NI_2 NS_92 0 1.9582798619828607e-06
GC_2_93 b_2 NI_2 NS_93 0 -1.0203616231556353e-04
GC_2_94 b_2 NI_2 NS_94 0 4.4958253774541216e-05
GC_2_95 b_2 NI_2 NS_95 0 3.0302070529613605e-07
GC_2_96 b_2 NI_2 NS_96 0 4.2331306342250294e-07
GC_2_97 b_2 NI_2 NS_97 0 2.0329540447002335e-04
GC_2_98 b_2 NI_2 NS_98 0 1.1753445365492298e-04
GC_2_99 b_2 NI_2 NS_99 0 1.2585007688232067e-05
GC_2_100 b_2 NI_2 NS_100 0 -2.2054304392836426e-06
GC_2_101 b_2 NI_2 NS_101 0 3.4872443455919241e-04
GC_2_102 b_2 NI_2 NS_102 0 2.9131180934260302e-04
GC_2_103 b_2 NI_2 NS_103 0 4.9148165904445021e-03
GC_2_104 b_2 NI_2 NS_104 0 3.2764453231560418e-04
GC_2_105 b_2 NI_2 NS_105 0 1.6292631855972971e-04
GC_2_106 b_2 NI_2 NS_106 0 3.3091876704467756e-05
GC_2_107 b_2 NI_2 NS_107 0 5.8131677326888579e-06
GC_2_108 b_2 NI_2 NS_108 0 -1.3102090526448833e-05
GC_2_109 b_2 NI_2 NS_109 0 -9.8499165495635949e-04
GC_2_110 b_2 NI_2 NS_110 0 -4.0792887223779225e-04
GC_2_111 b_2 NI_2 NS_111 0 -1.0148491187019950e-03
GC_2_112 b_2 NI_2 NS_112 0 -3.2328816674414451e-04
GC_2_113 b_2 NI_2 NS_113 0 -4.4511498375085284e-03
GC_2_114 b_2 NI_2 NS_114 0 9.0699845258306749e-04
GC_2_115 b_2 NI_2 NS_115 0 6.6281322397398569e-06
GC_2_116 b_2 NI_2 NS_116 0 1.5663498177807985e-05
GC_2_117 b_2 NI_2 NS_117 0 -2.8072149674585685e-05
GC_2_118 b_2 NI_2 NS_118 0 2.2498286522432970e-05
GC_2_119 b_2 NI_2 NS_119 0 1.4808711026054115e-05
GC_2_120 b_2 NI_2 NS_120 0 4.2864464632254182e-06
GC_2_121 b_2 NI_2 NS_121 0 2.1026790676758654e-03
GC_2_122 b_2 NI_2 NS_122 0 -5.5625631435494390e-05
GC_2_123 b_2 NI_2 NS_123 0 -1.1908642905997069e-03
GC_2_124 b_2 NI_2 NS_124 0 5.7068782034879395e-04
GC_2_125 b_2 NI_2 NS_125 0 9.3169891388192446e-04
GC_2_126 b_2 NI_2 NS_126 0 -2.9724822899944836e-05
GC_2_127 b_2 NI_2 NS_127 0 -1.0212840216357881e-07
GC_2_128 b_2 NI_2 NS_128 0 1.0782196225787534e-05
GC_2_129 b_2 NI_2 NS_129 0 2.3272369424396916e-05
GC_2_130 b_2 NI_2 NS_130 0 5.2505835388117527e-06
GC_2_131 b_2 NI_2 NS_131 0 -3.5620989006667457e-05
GC_2_132 b_2 NI_2 NS_132 0 -1.1054522158186602e-05
GC_2_133 b_2 NI_2 NS_133 0 -2.3634912315861621e-04
GC_2_134 b_2 NI_2 NS_134 0 9.4278717551639059e-05
GC_2_135 b_2 NI_2 NS_135 0 -2.0115668964735381e-07
GC_2_136 b_2 NI_2 NS_136 0 3.7896064884161078e-06
GC_2_137 b_2 NI_2 NS_137 0 -1.2358290136466629e-05
GC_2_138 b_2 NI_2 NS_138 0 -1.6332787694551054e-05
GC_2_139 b_2 NI_2 NS_139 0 -4.4167483240769986e-06
GC_2_140 b_2 NI_2 NS_140 0 -2.9380054528072829e-06
GD_2_1 b_2 NI_2 NA_1 0 -9.8975389470257300e-04
GD_2_2 b_2 NI_2 NA_2 0 6.1511393273119221e+00
GD_2_3 b_2 NI_2 NA_3 0 -3.6137285361079512e-02
GD_2_4 b_2 NI_2 NA_4 0 -1.0703350217237803e-02
GD_2_5 b_2 NI_2 NA_5 0 -1.7524239614636755e-03
GD_2_6 b_2 NI_2 NA_6 0 3.9278629812642936e-04
GD_2_7 b_2 NI_2 NA_7 0 -1.1324206618523827e-03
*
* Port 3
VI_3 a_3 NI_3 0
RI_3 NI_3 b_3 1.0000000000000001e-01
GC_3_1 b_3 NI_3 NS_1 0 2.0993119746563925e-03
GC_3_2 b_3 NI_3 NS_2 0 -5.5237820687202644e-05
GC_3_3 b_3 NI_3 NS_3 0 -1.6619384502591403e-03
GC_3_4 b_3 NI_3 NS_4 0 9.8763019639900424e-04
GC_3_5 b_3 NI_3 NS_5 0 8.8425286146662631e-04
GC_3_6 b_3 NI_3 NS_6 0 -6.5189585133351767e-05
GC_3_7 b_3 NI_3 NS_7 0 -1.3180229680516382e-05
GC_3_8 b_3 NI_3 NS_8 0 3.1640056783579726e-05
GC_3_9 b_3 NI_3 NS_9 0 -6.8325383063411890e-05
GC_3_10 b_3 NI_3 NS_10 0 -1.1023644473924847e-05
GC_3_11 b_3 NI_3 NS_11 0 3.2564265633377358e-04
GC_3_12 b_3 NI_3 NS_12 0 -8.0259375644896376e-06
GC_3_13 b_3 NI_3 NS_13 0 -2.8205453757711749e-04
GC_3_14 b_3 NI_3 NS_14 0 1.2011518389438507e-04
GC_3_15 b_3 NI_3 NS_15 0 7.3813743092115046e-07
GC_3_16 b_3 NI_3 NS_16 0 1.1108987803710151e-06
GC_3_17 b_3 NI_3 NS_17 0 -6.6150088084783278e-05
GC_3_18 b_3 NI_3 NS_18 0 -5.5266733241980461e-05
GC_3_19 b_3 NI_3 NS_19 0 -2.3158721261771879e-06
GC_3_20 b_3 NI_3 NS_20 0 -2.0700340374299825e-06
GC_3_21 b_3 NI_3 NS_21 0 5.6347892964396948e-02
GC_3_22 b_3 NI_3 NS_22 0 -1.4900616059080048e-05
GC_3_23 b_3 NI_3 NS_23 0 -7.3288038252399988e-04
GC_3_24 b_3 NI_3 NS_24 0 2.3338574616378993e-03
GC_3_25 b_3 NI_3 NS_25 0 3.0684908481573792e-04
GC_3_26 b_3 NI_3 NS_26 0 -1.5488867288087385e-04
GC_3_27 b_3 NI_3 NS_27 0 -3.5922212188747759e-05
GC_3_28 b_3 NI_3 NS_28 0 7.5413185425090570e-05
GC_3_29 b_3 NI_3 NS_29 0 -4.8653481441043475e-05
GC_3_30 b_3 NI_3 NS_30 0 -1.4226397979187680e-05
GC_3_31 b_3 NI_3 NS_31 0 -2.8035085498310716e-04
GC_3_32 b_3 NI_3 NS_32 0 -6.9530662361558950e-06
GC_3_33 b_3 NI_3 NS_33 0 -1.1456303889652044e-04
GC_3_34 b_3 NI_3 NS_34 0 7.0538732978819629e-05
GC_3_35 b_3 NI_3 NS_35 0 4.0634106041341693e-07
GC_3_36 b_3 NI_3 NS_36 0 2.1343013163205424e-07
GC_3_37 b_3 NI_3 NS_37 0 -1.2746069161574696e-04
GC_3_38 b_3 NI_3 NS_38 0 -1.0348890250911312e-04
GC_3_39 b_3 NI_3 NS_39 0 -1.5078100461757235e-05
GC_3_40 b_3 NI_3 NS_40 0 3.7050522811317754e-06
GC_3_41 b_3 NI_3 NS_41 0 2.9224274441405307e-01
GC_3_42 b_3 NI_3 NS_42 0 -1.5202659942930772e-04
GC_3_43 b_3 NI_3 NS_43 0 -1.4322547953446868e-03
GC_3_44 b_3 NI_3 NS_44 0 -5.3896282342163109e-03
GC_3_45 b_3 NI_3 NS_45 0 -3.1544516138882466e-03
GC_3_46 b_3 NI_3 NS_46 0 2.8141436768393216e-05
GC_3_47 b_3 NI_3 NS_47 0 -1.4543187909983754e-05
GC_3_48 b_3 NI_3 NS_48 0 6.5653004398814336e-06
GC_3_49 b_3 NI_3 NS_49 0 -8.6079486155021839e-05
GC_3_50 b_3 NI_3 NS_50 0 -4.9667873902668252e-05
GC_3_51 b_3 NI_3 NS_51 0 -3.2546553318649711e-04
GC_3_52 b_3 NI_3 NS_52 0 -6.3441539874160925e-06
GC_3_53 b_3 NI_3 NS_53 0 -1.0386675129047835e-04
GC_3_54 b_3 NI_3 NS_54 0 8.2678166676082641e-05
GC_3_55 b_3 NI_3 NS_55 0 5.9862993531027276e-07
GC_3_56 b_3 NI_3 NS_56 0 -8.1085525629386680e-07
GC_3_57 b_3 NI_3 NS_57 0 7.0409235469890409e-05
GC_3_58 b_3 NI_3 NS_58 0 2.4440113742345715e-05
GC_3_59 b_3 NI_3 NS_59 0 4.8721192501236588e-06
GC_3_60 b_3 NI_3 NS_60 0 -5.5228832196974047e-07
GC_3_61 b_3 NI_3 NS_61 0 9.4576201948278361e-03
GC_3_62 b_3 NI_3 NS_62 0 -2.4359984389277742e-05
GC_3_63 b_3 NI_3 NS_63 0 -8.3030403906930890e-04
GC_3_64 b_3 NI_3 NS_64 0 3.4937506976175343e-05
GC_3_65 b_3 NI_3 NS_65 0 1.2665889135063837e-03
GC_3_66 b_3 NI_3 NS_66 0 -4.0544598931582454e-05
GC_3_67 b_3 NI_3 NS_67 0 -6.1043653685087010e-06
GC_3_68 b_3 NI_3 NS_68 0 1.7652700336285854e-05
GC_3_69 b_3 NI_3 NS_69 0 3.5735469155944965e-05
GC_3_70 b_3 NI_3 NS_70 0 -4.5968544589966289e-06
GC_3_71 b_3 NI_3 NS_71 0 -1.6890186647103433e-04
GC_3_72 b_3 NI_3 NS_72 0 -1.4100149388097618e-05
GC_3_73 b_3 NI_3 NS_73 0 -1.5884701994864296e-04
GC_3_74 b_3 NI_3 NS_74 0 7.3061144761294420e-05
GC_3_75 b_3 NI_3 NS_75 0 4.2075528709145692e-07
GC_3_76 b_3 NI_3 NS_76 0 4.0599884925007458e-07
GC_3_77 b_3 NI_3 NS_77 0 -3.6075556590055257e-05
GC_3_78 b_3 NI_3 NS_78 0 -1.6190363296567952e-05
GC_3_79 b_3 NI_3 NS_79 0 -3.7631682106695875e-06
GC_3_80 b_3 NI_3 NS_80 0 -2.8735291438721098e-06
GC_3_81 b_3 NI_3 NS_81 0 2.2802251980190368e-03
GC_3_82 b_3 NI_3 NS_82 0 -3.0858617981372999e-05
GC_3_83 b_3 NI_3 NS_83 0 -7.2228832912455440e-04
GC_3_84 b_3 NI_3 NS_84 0 -3.5527258556431742e-04
GC_3_85 b_3 NI_3 NS_85 0 9.0994062488385747e-04
GC_3_86 b_3 NI_3 NS_86 0 1.3362404396776977e-04
GC_3_87 b_3 NI_3 NS_87 0 4.4370917629532090e-05
GC_3_88 b_3 NI_3 NS_88 0 -8.0032169427454998e-05
GC_3_89 b_3 NI_3 NS_89 0 -6.3652297007871456e-05
GC_3_90 b_3 NI_3 NS_90 0 -4.0355999747492846e-06
GC_3_91 b_3 NI_3 NS_91 0 1.5994986264852162e-04
GC_3_92 b_3 NI_3 NS_92 0 6.3481751585559185e-07
GC_3_93 b_3 NI_3 NS_93 0 -1.0474667364189341e-04
GC_3_94 b_3 NI_3 NS_94 0 5.5605359656361747e-05
GC_3_95 b_3 NI_3 NS_95 0 3.4654944748294615e-07
GC_3_96 b_3 NI_3 NS_96 0 4.2263575877225190e-07
GC_3_97 b_3 NI_3 NS_97 0 1.0141036654330366e-04
GC_3_98 b_3 NI_3 NS_98 0 5.9948297306818117e-05
GC_3_99 b_3 NI_3 NS_99 0 8.4078731888404110e-06
GC_3_100 b_3 NI_3 NS_100 0 -2.6852402668569300e-06
GC_3_101 b_3 NI_3 NS_101 0 9.2765311680806858e-02
GC_3_102 b_3 NI_3 NS_102 0 3.6405076038411357e-04
GC_3_103 b_3 NI_3 NS_103 0 7.1498563752151016e-03
GC_3_104 b_3 NI_3 NS_104 0 2.8863337468393541e-04
GC_3_105 b_3 NI_3 NS_105 0 -1.0789618596373345e-04
GC_3_106 b_3 NI_3 NS_106 0 -1.0493391670605219e-05
GC_3_107 b_3 NI_3 NS_107 0 3.6301238121431005e-06
GC_3_108 b_3 NI_3 NS_108 0 -3.4463817403517973e-06
GC_3_109 b_3 NI_3 NS_109 0 -1.4686217739855153e-03
GC_3_110 b_3 NI_3 NS_110 0 -5.0377275319291276e-04
GC_3_111 b_3 NI_3 NS_111 0 -1.1853268407791492e-03
GC_3_112 b_3 NI_3 NS_112 0 -3.6594061147971000e-04
GC_3_113 b_3 NI_3 NS_113 0 -4.6500467410541440e-03
GC_3_114 b_3 NI_3 NS_114 0 1.3228825890988624e-03
GC_3_115 b_3 NI_3 NS_115 0 9.1045561412156445e-06
GC_3_116 b_3 NI_3 NS_116 0 1.5900089816176903e-05
GC_3_117 b_3 NI_3 NS_117 0 2.2281130323613438e-05
GC_3_118 b_3 NI_3 NS_118 0 -3.2110576397635102e-05
GC_3_119 b_3 NI_3 NS_119 0 -8.9665107240188338e-06
GC_3_120 b_3 NI_3 NS_120 0 5.2884233109404625e-06
GC_3_121 b_3 NI_3 NS_121 0 1.9572627452564939e-02
GC_3_122 b_3 NI_3 NS_122 0 -9.0518399355466153e-05
GC_3_123 b_3 NI_3 NS_123 0 -1.6891809952636998e-03
GC_3_124 b_3 NI_3 NS_124 0 2.0446448286217497e-03
GC_3_125 b_3 NI_3 NS_125 0 -1.2008616554156082e-05
GC_3_126 b_3 NI_3 NS_126 0 6.8694571868391810e-05
GC_3_127 b_3 NI_3 NS_127 0 1.2443909619958119e-05
GC_3_128 b_3 NI_3 NS_128 0 -2.7148791744478300e-05
GC_3_129 b_3 NI_3 NS_129 0 2.4995756412146264e-05
GC_3_130 b_3 NI_3 NS_130 0 5.1653388326346798e-06
GC_3_131 b_3 NI_3 NS_131 0 -4.1952340090624839e-05
GC_3_132 b_3 NI_3 NS_132 0 -1.2335965308405476e-05
GC_3_133 b_3 NI_3 NS_133 0 -2.4517788467304566e-04
GC_3_134 b_3 NI_3 NS_134 0 1.1796665822988427e-04
GC_3_135 b_3 NI_3 NS_135 0 4.2572380076719037e-08
GC_3_136 b_3 NI_3 NS_136 0 4.3646242381706379e-06
GC_3_137 b_3 NI_3 NS_137 0 2.2953072983953599e-05
GC_3_138 b_3 NI_3 NS_138 0 8.1523917667534286e-05
GC_3_139 b_3 NI_3 NS_139 0 1.2385680840129635e-05
GC_3_140 b_3 NI_3 NS_140 0 -1.9477449391566385e-06
GD_3_1 b_3 NI_3 NA_1 0 -1.3130924649199936e-03
GD_3_2 b_3 NI_3 NA_2 0 -3.6137285361079512e-02
GD_3_3 b_3 NI_3 NA_3 0 6.1354120438795592e+00
GD_3_4 b_3 NI_3 NA_4 0 -6.0861450739651919e-03
GD_3_5 b_3 NI_3 NA_5 0 -1.4066963196365174e-03
GD_3_6 b_3 NI_3 NA_6 0 -5.8443931552179376e-02
GD_3_7 b_3 NI_3 NA_7 0 -1.2220400485516042e-02
*
* Port 4
VI_4 a_4 NI_4 0
RI_4 NI_4 b_4 1.0000000000000001e-01
GC_4_1 b_4 NI_4 NS_1 0 -1.4913895408655582e-03
GC_4_2 b_4 NI_4 NS_2 0 -4.0461957749438362e-05
GC_4_3 b_4 NI_4 NS_3 0 -1.1967740035625566e-03
GC_4_4 b_4 NI_4 NS_4 0 2.3028994823810547e-04
GC_4_5 b_4 NI_4 NS_5 0 1.2897461833720797e-03
GC_4_6 b_4 NI_4 NS_6 0 -9.8721277932726711e-05
GC_4_7 b_4 NI_4 NS_7 0 -1.4919189089158637e-05
GC_4_8 b_4 NI_4 NS_8 0 4.1289973607895508e-05
GC_4_9 b_4 NI_4 NS_9 0 4.1296346406406373e-05
GC_4_10 b_4 NI_4 NS_10 0 -2.2385971401784570e-06
GC_4_11 b_4 NI_4 NS_11 0 1.6884017207407045e-04
GC_4_12 b_4 NI_4 NS_12 0 7.2072646018814566e-06
GC_4_13 b_4 NI_4 NS_13 0 -3.6706430634635926e-04
GC_4_14 b_4 NI_4 NS_14 0 7.7032411520676860e-05
GC_4_15 b_4 NI_4 NS_15 0 2.4507787381590992e-07
GC_4_16 b_4 NI_4 NS_16 0 1.7196529262923273e-06
GC_4_17 b_4 NI_4 NS_17 0 -5.7118862202810746e-05
GC_4_18 b_4 NI_4 NS_18 0 -9.1636568789026608e-05
GC_4_19 b_4 NI_4 NS_19 0 -1.3130974631670371e-05
GC_4_20 b_4 NI_4 NS_20 0 -1.9091989452798374e-06
GC_4_21 b_4 NI_4 NS_21 0 1.6711071476495854e-02
GC_4_22 b_4 NI_4 NS_22 0 -2.2390160693020319e-05
GC_4_23 b_4 NI_4 NS_23 0 -5.5471271208772717e-04
GC_4_24 b_4 NI_4 NS_24 0 -6.9413842415296328e-05
GC_4_25 b_4 NI_4 NS_25 0 1.1005601442115290e-03
GC_4_26 b_4 NI_4 NS_26 0 4.8889132446521170e-05
GC_4_27 b_4 NI_4 NS_27 0 1.7186181829475448e-05
GC_4_28 b_4 NI_4 NS_28 0 -3.0115273539780672e-05
GC_4_29 b_4 NI_4 NS_29 0 2.4705118794096391e-05
GC_4_30 b_4 NI_4 NS_30 0 -1.0844485082696160e-06
GC_4_31 b_4 NI_4 NS_31 0 -1.4488176994124349e-04
GC_4_32 b_4 NI_4 NS_32 0 -1.3368685093386784e-05
GC_4_33 b_4 NI_4 NS_33 0 -1.5420366508208790e-04
GC_4_34 b_4 NI_4 NS_34 0 5.7376031599230300e-05
GC_4_35 b_4 NI_4 NS_35 0 3.6416844424736076e-07
GC_4_36 b_4 NI_4 NS_36 0 4.5211340710745911e-07
GC_4_37 b_4 NI_4 NS_37 0 -4.3594671079703852e-06
GC_4_38 b_4 NI_4 NS_38 0 4.8276509901633825e-05
GC_4_39 b_4 NI_4 NS_39 0 8.4619189024792144e-06
GC_4_40 b_4 NI_4 NS_40 0 -8.6764392940775011e-08
GC_4_41 b_4 NI_4 NS_41 0 9.4576201948278361e-03
GC_4_42 b_4 NI_4 NS_42 0 -2.4359984389277742e-05
GC_4_43 b_4 NI_4 NS_43 0 -8.3030403906930890e-04
GC_4_44 b_4 NI_4 NS_44 0 3.4937506976175343e-05
GC_4_45 b_4 NI_4 NS_45 0 1.2665889135063837e-03
GC_4_46 b_4 NI_4 NS_46 0 -4.0544598931582454e-05
GC_4_47 b_4 NI_4 NS_47 0 -6.1043653685087010e-06
GC_4_48 b_4 NI_4 NS_48 0 1.7652700336285854e-05
GC_4_49 b_4 NI_4 NS_49 0 3.5735469155944965e-05
GC_4_50 b_4 NI_4 NS_50 0 -4.5968544589966289e-06
GC_4_51 b_4 NI_4 NS_51 0 -1.6890186647103433e-04
GC_4_52 b_4 NI_4 NS_52 0 -1.4100149388097618e-05
GC_4_53 b_4 NI_4 NS_53 0 -1.5884701994864296e-04
GC_4_54 b_4 NI_4 NS_54 0 7.3061144761294420e-05
GC_4_55 b_4 NI_4 NS_55 0 4.2075528709145692e-07
GC_4_56 b_4 NI_4 NS_56 0 4.0599884925007458e-07
GC_4_57 b_4 NI_4 NS_57 0 -3.6075556590055257e-05
GC_4_58 b_4 NI_4 NS_58 0 -1.6190363296567952e-05
GC_4_59 b_4 NI_4 NS_59 0 -3.7631682106695875e-06
GC_4_60 b_4 NI_4 NS_60 0 -2.8735291438721098e-06
GC_4_61 b_4 NI_4 NS_61 0 2.2243751207240167e-01
GC_4_62 b_4 NI_4 NS_62 0 -8.6379676429070113e-05
GC_4_63 b_4 NI_4 NS_63 0 -7.7260336340450404e-04
GC_4_64 b_4 NI_4 NS_64 0 -1.6652879308761146e-03
GC_4_65 b_4 NI_4 NS_65 0 -4.8462936517024401e-03
GC_4_66 b_4 NI_4 NS_66 0 -1.5019230111386583e-04
GC_4_67 b_4 NI_4 NS_67 0 -6.7549849759873822e-05
GC_4_68 b_4 NI_4 NS_68 0 1.0349563601032134e-04
GC_4_69 b_4 NI_4 NS_69 0 -4.4509697350023182e-05
GC_4_70 b_4 NI_4 NS_70 0 -1.0442363278277427e-05
GC_4_71 b_4 NI_4 NS_71 0 -8.5586794839630654e-05
GC_4_72 b_4 NI_4 NS_72 0 -1.3173462077119380e-05
GC_4_73 b_4 NI_4 NS_73 0 -1.9817733523940564e-04
GC_4_74 b_4 NI_4 NS_74 0 5.1779779811813552e-05
GC_4_75 b_4 NI_4 NS_75 0 5.9701184222221648e-07
GC_4_76 b_4 NI_4 NS_76 0 -1.1664142410709916e-07
GC_4_77 b_4 NI_4 NS_77 0 -2.4554928999778562e-05
GC_4_78 b_4 NI_4 NS_78 0 -7.6262078405875470e-05
GC_4_79 b_4 NI_4 NS_79 0 -1.9569768334142825e-05
GC_4_80 b_4 NI_4 NS_80 0 2.5690758645179287e-06
GC_4_81 b_4 NI_4 NS_81 0 4.4147373636577291e-03
GC_4_82 b_4 NI_4 NS_82 0 -2.8325151433913322e-05
GC_4_83 b_4 NI_4 NS_83 0 -5.0496158344499442e-04
GC_4_84 b_4 NI_4 NS_84 0 -4.7682602685795978e-04
GC_4_85 b_4 NI_4 NS_85 0 7.2173659974016308e-04
GC_4_86 b_4 NI_4 NS_86 0 1.9321239420672402e-04
GC_4_87 b_4 NI_4 NS_87 0 6.2864359347546036e-05
GC_4_88 b_4 NI_4 NS_88 0 -1.1436071649522990e-04
GC_4_89 b_4 NI_4 NS_89 0 3.4700803071803952e-05
GC_4_90 b_4 NI_4 NS_90 0 -5.3592684802703887e-06
GC_4_91 b_4 NI_4 NS_91 0 8.2725037155591827e-05
GC_4_92 b_4 NI_4 NS_92 0 5.9047188795264174e-06
GC_4_93 b_4 NI_4 NS_93 0 -1.3895922545696573e-04
GC_4_94 b_4 NI_4 NS_94 0 4.1793329249184175e-05
GC_4_95 b_4 NI_4 NS_95 0 1.8404722339707697e-07
GC_4_96 b_4 NI_4 NS_96 0 6.9338390900970453e-07
GC_4_97 b_4 NI_4 NS_97 0 1.7698637879344311e-04
GC_4_98 b_4 NI_4 NS_98 0 8.2269849827268623e-05
GC_4_99 b_4 NI_4 NS_99 0 6.6850829070130194e-06
GC_4_100 b_4 NI_4 NS_100 0 -7.9917672547795334e-07
GC_4_101 b_4 NI_4 NS_101 0 9.2526219391421971e-02
GC_4_102 b_4 NI_4 NS_102 0 2.7950610505262535e-04
GC_4_103 b_4 NI_4 NS_103 0 5.0989187859979265e-03
GC_4_104 b_4 NI_4 NS_104 0 3.6722036135917183e-04
GC_4_105 b_4 NI_4 NS_105 0 1.3547884168633591e-04
GC_4_106 b_4 NI_4 NS_106 0 1.2627791316483447e-05
GC_4_107 b_4 NI_4 NS_107 0 6.8617790655666327e-07
GC_4_108 b_4 NI_4 NS_108 0 -2.3080849372158683e-06
GC_4_109 b_4 NI_4 NS_109 0 8.0048296332144977e-04
GC_4_110 b_4 NI_4 NS_110 0 1.6000166607780102e-05
GC_4_111 b_4 NI_4 NS_111 0 -6.0086349887383253e-04
GC_4_112 b_4 NI_4 NS_112 0 -2.3243874575148602e-04
GC_4_113 b_4 NI_4 NS_113 0 -5.8889396947001725e-03
GC_4_114 b_4 NI_4 NS_114 0 4.8099796407497213e-04
GC_4_115 b_4 NI_4 NS_115 0 1.5988714173589190e-06
GC_4_116 b_4 NI_4 NS_116 0 2.3151428898637525e-05
GC_4_117 b_4 NI_4 NS_117 0 -2.0694714688540948e-05
GC_4_118 b_4 NI_4 NS_118 0 6.4046453371814489e-06
GC_4_119 b_4 NI_4 NS_119 0 1.0264588830363117e-05
GC_4_120 b_4 NI_4 NS_120 0 2.5430340995339812e-06
GC_4_121 b_4 NI_4 NS_121 0 3.7258824442062431e-02
GC_4_122 b_4 NI_4 NS_122 0 -5.7416808948478225e-05
GC_4_123 b_4 NI_4 NS_123 0 -1.2059496672899956e-03
GC_4_124 b_4 NI_4 NS_124 0 1.5991883249160007e-03
GC_4_125 b_4 NI_4 NS_125 0 3.1124453908692350e-04
GC_4_126 b_4 NI_4 NS_126 0 3.8558590114100508e-05
GC_4_127 b_4 NI_4 NS_127 0 8.7976974470586911e-06
GC_4_128 b_4 NI_4 NS_128 0 -1.7601772206349506e-05
GC_4_129 b_4 NI_4 NS_129 0 -3.8973023650943909e-05
GC_4_130 b_4 NI_4 NS_130 0 -4.8529744304759713e-06
GC_4_131 b_4 NI_4 NS_131 0 -2.1096478360744936e-05
GC_4_132 b_4 NI_4 NS_132 0 -8.2825402361677563e-06
GC_4_133 b_4 NI_4 NS_133 0 -3.1725287800899555e-04
GC_4_134 b_4 NI_4 NS_134 0 8.2351202221541553e-05
GC_4_135 b_4 NI_4 NS_135 0 -2.2130538569624267e-06
GC_4_136 b_4 NI_4 NS_136 0 4.6786706095958845e-06
GC_4_137 b_4 NI_4 NS_137 0 -3.0055213268807070e-05
GC_4_138 b_4 NI_4 NS_138 0 5.0846022430689658e-05
GC_4_139 b_4 NI_4 NS_139 0 1.1336241635470970e-05
GC_4_140 b_4 NI_4 NS_140 0 4.7369136385181707e-07
GD_4_1 b_4 NI_4 NA_1 0 1.0045987827434918e-03
GD_4_2 b_4 NI_4 NA_2 0 -1.0703350217237803e-02
GD_4_3 b_4 NI_4 NA_3 0 -6.0861450739651919e-03
GD_4_4 b_4 NI_4 NA_4 0 6.1806517145744690e+00
GD_4_5 b_4 NI_4 NA_5 0 -2.7735030075792199e-03
GD_4_6 b_4 NI_4 NA_6 0 -5.8539741542289345e-02
GD_4_7 b_4 NI_4 NA_7 0 -2.3965622995677154e-02
*
* Port 5
VI_5 a_5 NI_5 0
RI_5 NI_5 b_5 1.0000000000000001e-01
GC_5_1 b_5 NI_5 NS_1 0 1.6826022122433174e-02
GC_5_2 b_5 NI_5 NS_2 0 -3.5019067994772218e-05
GC_5_3 b_5 NI_5 NS_3 0 -1.0519884569861011e-03
GC_5_4 b_5 NI_5 NS_4 0 1.0237325246280928e-03
GC_5_5 b_5 NI_5 NS_5 0 9.8433488057727333e-04
GC_5_6 b_5 NI_5 NS_6 0 -1.1444482683898872e-04
GC_5_7 b_5 NI_5 NS_7 0 -2.5564736064395268e-05
GC_5_8 b_5 NI_5 NS_8 0 5.3204477640887909e-05
GC_5_9 b_5 NI_5 NS_9 0 -6.9030308959221225e-05
GC_5_10 b_5 NI_5 NS_10 0 -6.5930410542319848e-06
GC_5_11 b_5 NI_5 NS_11 0 -1.5940879856386129e-04
GC_5_12 b_5 NI_5 NS_12 0 6.1015920200245263e-06
GC_5_13 b_5 NI_5 NS_13 0 -2.4452462846571152e-04
GC_5_14 b_5 NI_5 NS_14 0 6.4432296002682661e-05
GC_5_15 b_5 NI_5 NS_15 0 -5.1094850598126288e-08
GC_5_16 b_5 NI_5 NS_16 0 1.4406663861484951e-06
GC_5_17 b_5 NI_5 NS_17 0 -9.9863741645719571e-05
GC_5_18 b_5 NI_5 NS_18 0 -9.5115042664237391e-05
GC_5_19 b_5 NI_5 NS_19 0 -1.1053292579860759e-05
GC_5_20 b_5 NI_5 NS_20 0 5.8356197776385533e-06
GC_5_21 b_5 NI_5 NS_21 0 2.8536263718977246e-03
GC_5_22 b_5 NI_5 NS_22 0 -2.8217694109996332e-05
GC_5_23 b_5 NI_5 NS_23 0 -4.8606322974587701e-04
GC_5_24 b_5 NI_5 NS_24 0 -4.2182228873843461e-04
GC_5_25 b_5 NI_5 NS_25 0 5.5160903990095916e-04
GC_5_26 b_5 NI_5 NS_26 0 2.4115001380388705e-04
GC_5_27 b_5 NI_5 NS_27 0 7.3975545741972916e-05
GC_5_28 b_5 NI_5 NS_28 0 -1.3702751418197162e-04
GC_5_29 b_5 NI_5 NS_29 0 -4.3215523290993496e-05
GC_5_30 b_5 NI_5 NS_30 0 -4.6651573168444194e-06
GC_5_31 b_5 NI_5 NS_31 0 1.3733887935975852e-04
GC_5_32 b_5 NI_5 NS_32 0 1.9582798619828607e-06
GC_5_33 b_5 NI_5 NS_33 0 -1.0203616231556353e-04
GC_5_34 b_5 NI_5 NS_34 0 4.4958253774541216e-05
GC_5_35 b_5 NI_5 NS_35 0 3.0302070529613605e-07
GC_5_36 b_5 NI_5 NS_36 0 4.2331306342250294e-07
GC_5_37 b_5 NI_5 NS_37 0 2.0329540447002335e-04
GC_5_38 b_5 NI_5 NS_38 0 1.1753445365492298e-04
GC_5_39 b_5 NI_5 NS_39 0 1.2585007688232067e-05
GC_5_40 b_5 NI_5 NS_40 0 -2.2054304392836426e-06
GC_5_41 b_5 NI_5 NS_41 0 2.2802251980190368e-03
GC_5_42 b_5 NI_5 NS_42 0 -3.0858617981372999e-05
GC_5_43 b_5 NI_5 NS_43 0 -7.2228832912455440e-04
GC_5_44 b_5 NI_5 NS_44 0 -3.5527258556431742e-04
GC_5_45 b_5 NI_5 NS_45 0 9.0994062488385747e-04
GC_5_46 b_5 NI_5 NS_46 0 1.3362404396776977e-04
GC_5_47 b_5 NI_5 NS_47 0 4.4370917629532090e-05
GC_5_48 b_5 NI_5 NS_48 0 -8.0032169427454998e-05
GC_5_49 b_5 NI_5 NS_49 0 -6.3652297007871456e-05
GC_5_50 b_5 NI_5 NS_50 0 -4.0355999747492846e-06
GC_5_51 b_5 NI_5 NS_51 0 1.5994986264852162e-04
GC_5_52 b_5 NI_5 NS_52 0 6.3481751585559185e-07
GC_5_53 b_5 NI_5 NS_53 0 -1.0474667364189341e-04
GC_5_54 b_5 NI_5 NS_54 0 5.5605359656361747e-05
GC_5_55 b_5 NI_5 NS_55 0 3.4654944748294615e-07
GC_5_56 b_5 NI_5 NS_56 0 4.2263575877225190e-07
GC_5_57 b_5 NI_5 NS_57 0 1.0141036654330366e-04
GC_5_58 b_5 NI_5 NS_58 0 5.9948297306818117e-05
GC_5_59 b_5 NI_5 NS_59 0 8.4078731888404110e-06
GC_5_60 b_5 NI_5 NS_60 0 -2.6852402668569300e-06
GC_5_61 b_5 NI_5 NS_61 0 4.4147373636577291e-03
GC_5_62 b_5 NI_5 NS_62 0 -2.8325151433913322e-05
GC_5_63 b_5 NI_5 NS_63 0 -5.0496158344499442e-04
GC_5_64 b_5 NI_5 NS_64 0 -4.7682602685795978e-04
GC_5_65 b_5 NI_5 NS_65 0 7.2173659974016308e-04
GC_5_66 b_5 NI_5 NS_66 0 1.9321239420672402e-04
GC_5_67 b_5 NI_5 NS_67 0 6.2864359347546036e-05
GC_5_68 b_5 NI_5 NS_68 0 -1.1436071649522990e-04
GC_5_69 b_5 NI_5 NS_69 0 3.4700803071803952e-05
GC_5_70 b_5 NI_5 NS_70 0 -5.3592684802703887e-06
GC_5_71 b_5 NI_5 NS_71 0 8.2725037155591827e-05
GC_5_72 b_5 NI_5 NS_72 0 5.9047188795264174e-06
GC_5_73 b_5 NI_5 NS_73 0 -1.3895922545696573e-04
GC_5_74 b_5 NI_5 NS_74 0 4.1793329249184175e-05
GC_5_75 b_5 NI_5 NS_75 0 1.8404722339707697e-07
GC_5_76 b_5 NI_5 NS_76 0 6.9338390900970453e-07
GC_5_77 b_5 NI_5 NS_77 0 1.7698637879344311e-04
GC_5_78 b_5 NI_5 NS_78 0 8.2269849827268623e-05
GC_5_79 b_5 NI_5 NS_79 0 6.6850829070130194e-06
GC_5_80 b_5 NI_5 NS_80 0 -7.9917672547795334e-07
GC_5_81 b_5 NI_5 NS_81 0 2.3210352585678581e-01
GC_5_82 b_5 NI_5 NS_82 0 -3.5402660850215175e-06
GC_5_83 b_5 NI_5 NS_83 0 -6.7687536338788116e-04
GC_5_84 b_5 NI_5 NS_84 0 -4.3202703074797814e-04
GC_5_85 b_5 NI_5 NS_85 0 -4.4369438491781918e-03
GC_5_86 b_5 NI_5 NS_86 0 -4.4140604417802331e-04
GC_5_87 b_5 NI_5 NS_87 0 -1.5702088543522794e-04
GC_5_88 b_5 NI_5 NS_88 0 2.7337404067475599e-04
GC_5_89 b_5 NI_5 NS_89 0 -6.8501205471947874e-05
GC_5_90 b_5 NI_5 NS_90 0 -2.7904892186625434e-05
GC_5_91 b_5 NI_5 NS_91 0 -7.5429165277294061e-05
GC_5_92 b_5 NI_5 NS_92 0 6.9101396260329209e-07
GC_5_93 b_5 NI_5 NS_93 0 -7.1993876817880821e-05
GC_5_94 b_5 NI_5 NS_94 0 3.3658065692633369e-05
GC_5_95 b_5 NI_5 NS_95 0 4.2878103000834453e-07
GC_5_96 b_5 NI_5 NS_96 0 -1.2851070818598661e-06
GC_5_97 b_5 NI_5 NS_97 0 -3.3965438057330914e-04
GC_5_98 b_5 NI_5 NS_98 0 -1.3587560771746553e-04
GC_5_99 b_5 NI_5 NS_99 0 -2.6349916947587034e-05
GC_5_100 b_5 NI_5 NS_100 0 3.3037951848234858e-06
GC_5_101 b_5 NI_5 NS_101 0 9.1430448940644754e-02
GC_5_102 b_5 NI_5 NS_102 0 2.3325334000894949e-04
GC_5_103 b_5 NI_5 NS_103 0 4.5291254877709297e-03
GC_5_104 b_5 NI_5 NS_104 0 3.5032276061549786e-04
GC_5_105 b_5 NI_5 NS_105 0 1.4512785851848183e-04
GC_5_106 b_5 NI_5 NS_106 0 7.0835260448179471e-05
GC_5_107 b_5 NI_5 NS_107 0 1.5109990897162236e-05
GC_5_108 b_5 NI_5 NS_108 0 -3.3782792006033493e-05
GC_5_109 b_5 NI_5 NS_109 0 -1.4744945996405065e-03
GC_5_110 b_5 NI_5 NS_110 0 -3.6303311646598152e-04
GC_5_111 b_5 NI_5 NS_111 0 5.8194136059597560e-04
GC_5_112 b_5 NI_5 NS_112 0 1.7168631076695820e-04
GC_5_113 b_5 NI_5 NS_113 0 -3.9519384814062225e-03
GC_5_114 b_5 NI_5 NS_114 0 5.3090093183472923e-04
GC_5_115 b_5 NI_5 NS_115 0 -1.7492762665439044e-06
GC_5_116 b_5 NI_5 NS_116 0 1.9427469494851964e-05
GC_5_117 b_5 NI_5 NS_117 0 -1.5866327273170136e-05
GC_5_118 b_5 NI_5 NS_118 0 5.9538163262153496e-05
GC_5_119 b_5 NI_5 NS_119 0 1.9355124729647526e-05
GC_5_120 b_5 NI_5 NS_120 0 1.6537158097376672e-06
GC_5_121 b_5 NI_5 NS_121 0 1.4049076480680874e-02
GC_5_122 b_5 NI_5 NS_122 0 -4.6461403082938461e-05
GC_5_123 b_5 NI_5 NS_123 0 -1.1045204655880617e-03
GC_5_124 b_5 NI_5 NS_124 0 4.4903781420277243e-04
GC_5_125 b_5 NI_5 NS_125 0 9.1385984593493283e-04
GC_5_126 b_5 NI_5 NS_126 0 4.5179481131550357e-06
GC_5_127 b_5 NI_5 NS_127 0 9.3414027101718172e-06
GC_5_128 b_5 NI_5 NS_128 0 -9.8746727739594443e-06
GC_5_129 b_5 NI_5 NS_129 0 1.8525358302495641e-05
GC_5_130 b_5 NI_5 NS_130 0 -4.7614944138842787e-06
GC_5_131 b_5 NI_5 NS_131 0 2.0568655369277754e-05
GC_5_132 b_5 NI_5 NS_132 0 5.6132058817885974e-06
GC_5_133 b_5 NI_5 NS_133 0 -2.1064892893259046e-04
GC_5_134 b_5 NI_5 NS_134 0 6.7024159830907462e-05
GC_5_135 b_5 NI_5 NS_135 0 -2.3989945726948529e-06
GC_5_136 b_5 NI_5 NS_136 0 3.5615852879957008e-06
GC_5_137 b_5 NI_5 NS_137 0 1.6768961041578855e-06
GC_5_138 b_5 NI_5 NS_138 0 -4.7805353818183741e-06
GC_5_139 b_5 NI_5 NS_139 0 -9.7655190876824187e-07
GC_5_140 b_5 NI_5 NS_140 0 -2.4759347417813168e-06
GD_5_1 b_5 NI_5 NA_1 0 -1.0796798789852773e-02
GD_5_2 b_5 NI_5 NA_2 0 -1.7524239614636755e-03
GD_5_3 b_5 NI_5 NA_3 0 -1.4066963196365174e-03
GD_5_4 b_5 NI_5 NA_4 0 -2.7735030075792199e-03
GD_5_5 b_5 NI_5 NA_5 0 6.1736080534549949e+00
GD_5_6 b_5 NI_5 NA_6 0 -5.7847712009665014e-02
GD_5_7 b_5 NI_5 NA_7 0 -9.0309340383733713e-03
*
* Port 6
VI_6 a_6 NI_6 0
RI_6 NI_6 b_6 1.0000000000000001e-01
GC_6_1 b_6 NI_6 NS_1 0 6.5042636224139277e-02
GC_6_2 b_6 NI_6 NS_2 0 5.4946027244558572e-04
GC_6_3 b_6 NI_6 NS_3 0 1.0300356406854951e-02
GC_6_4 b_6 NI_6 NS_4 0 4.5278315904991664e-06
GC_6_5 b_6 NI_6 NS_5 0 -4.4679043910123581e-04
GC_6_6 b_6 NI_6 NS_6 0 -1.0600045573846383e-05
GC_6_7 b_6 NI_6 NS_7 0 -4.7071145524683741e-06
GC_6_8 b_6 NI_6 NS_8 0 8.7547622446845545e-06
GC_6_9 b_6 NI_6 NS_9 0 -1.5225651951166859e-03
GC_6_10 b_6 NI_6 NS_10 0 -5.0105361245458705e-04
GC_6_11 b_6 NI_6 NS_11 0 1.1939376044745880e-03
GC_6_12 b_6 NI_6 NS_12 0 3.1798127644716811e-04
GC_6_13 b_6 NI_6 NS_13 0 -1.0336155168954482e-02
GC_6_14 b_6 NI_6 NS_14 0 5.3486215898866673e-04
GC_6_15 b_6 NI_6 NS_15 0 -7.2515478702338389e-06
GC_6_16 b_6 NI_6 NS_16 0 5.0608992420712003e-05
GC_6_17 b_6 NI_6 NS_17 0 5.5316440494803323e-05
GC_6_18 b_6 NI_6 NS_18 0 -1.1600763263878479e-05
GC_6_19 b_6 NI_6 NS_19 0 -9.4275319764900364e-06
GC_6_20 b_6 NI_6 NS_20 0 -1.2124178784777161e-06
GC_6_21 b_6 NI_6 NS_21 0 3.4872443455919241e-04
GC_6_22 b_6 NI_6 NS_22 0 2.9131180934260302e-04
GC_6_23 b_6 NI_6 NS_23 0 4.9148165904445021e-03
GC_6_24 b_6 NI_6 NS_24 0 3.2764453231560418e-04
GC_6_25 b_6 NI_6 NS_25 0 1.6292631855972971e-04
GC_6_26 b_6 NI_6 NS_26 0 3.3091876704467756e-05
GC_6_27 b_6 NI_6 NS_27 0 5.8131677326888579e-06
GC_6_28 b_6 NI_6 NS_28 0 -1.3102090526448833e-05
GC_6_29 b_6 NI_6 NS_29 0 -9.8499165495635949e-04
GC_6_30 b_6 NI_6 NS_30 0 -4.0792887223779225e-04
GC_6_31 b_6 NI_6 NS_31 0 -1.0148491187019950e-03
GC_6_32 b_6 NI_6 NS_32 0 -3.2328816674414451e-04
GC_6_33 b_6 NI_6 NS_33 0 -4.4511498375085284e-03
GC_6_34 b_6 NI_6 NS_34 0 9.0699845258306749e-04
GC_6_35 b_6 NI_6 NS_35 0 6.6281322397398569e-06
GC_6_36 b_6 NI_6 NS_36 0 1.5663498177807985e-05
GC_6_37 b_6 NI_6 NS_37 0 -2.8072149674585685e-05
GC_6_38 b_6 NI_6 NS_38 0 2.2498286522432970e-05
GC_6_39 b_6 NI_6 NS_39 0 1.4808711026054115e-05
GC_6_40 b_6 NI_6 NS_40 0 4.2864464632254182e-06
GC_6_41 b_6 NI_6 NS_41 0 9.2765311680806858e-02
GC_6_42 b_6 NI_6 NS_42 0 3.6405076038411357e-04
GC_6_43 b_6 NI_6 NS_43 0 7.1498563752151016e-03
GC_6_44 b_6 NI_6 NS_44 0 2.8863337468393541e-04
GC_6_45 b_6 NI_6 NS_45 0 -1.0789618596373345e-04
GC_6_46 b_6 NI_6 NS_46 0 -1.0493391670605219e-05
GC_6_47 b_6 NI_6 NS_47 0 3.6301238121431005e-06
GC_6_48 b_6 NI_6 NS_48 0 -3.4463817403517973e-06
GC_6_49 b_6 NI_6 NS_49 0 -1.4686217739855153e-03
GC_6_50 b_6 NI_6 NS_50 0 -5.0377275319291276e-04
GC_6_51 b_6 NI_6 NS_51 0 -1.1853268407791492e-03
GC_6_52 b_6 NI_6 NS_52 0 -3.6594061147971000e-04
GC_6_53 b_6 NI_6 NS_53 0 -4.6500467410541440e-03
GC_6_54 b_6 NI_6 NS_54 0 1.3228825890988624e-03
GC_6_55 b_6 NI_6 NS_55 0 9.1045561412156445e-06
GC_6_56 b_6 NI_6 NS_56 0 1.5900089816176903e-05
GC_6_57 b_6 NI_6 NS_57 0 2.2281130323613438e-05
GC_6_58 b_6 NI_6 NS_58 0 -3.2110576397635102e-05
GC_6_59 b_6 NI_6 NS_59 0 -8.9665107240188338e-06
GC_6_60 b_6 NI_6 NS_60 0 5.2884233109404625e-06
GC_6_61 b_6 NI_6 NS_61 0 9.2526219391421971e-02
GC_6_62 b_6 NI_6 NS_62 0 2.7950610505262535e-04
GC_6_63 b_6 NI_6 NS_63 0 5.0989187859979265e-03
GC_6_64 b_6 NI_6 NS_64 0 3.6722036135917183e-04
GC_6_65 b_6 NI_6 NS_65 0 1.3547884168633591e-04
GC_6_66 b_6 NI_6 NS_66 0 1.2627791316483447e-05
GC_6_67 b_6 NI_6 NS_67 0 6.8617790655666327e-07
GC_6_68 b_6 NI_6 NS_68 0 -2.3080849372158683e-06
GC_6_69 b_6 NI_6 NS_69 0 8.0048296332144977e-04
GC_6_70 b_6 NI_6 NS_70 0 1.6000166607780102e-05
GC_6_71 b_6 NI_6 NS_71 0 -6.0086349887383253e-04
GC_6_72 b_6 NI_6 NS_72 0 -2.3243874575148602e-04
GC_6_73 b_6 NI_6 NS_73 0 -5.8889396947001725e-03
GC_6_74 b_6 NI_6 NS_74 0 4.8099796407497213e-04
GC_6_75 b_6 NI_6 NS_75 0 1.5988714173589190e-06
GC_6_76 b_6 NI_6 NS_76 0 2.3151428898637525e-05
GC_6_77 b_6 NI_6 NS_77 0 -2.0694714688540948e-05
GC_6_78 b_6 NI_6 NS_78 0 6.4046453371814489e-06
GC_6_79 b_6 NI_6 NS_79 0 1.0264588830363117e-05
GC_6_80 b_6 NI_6 NS_80 0 2.5430340995339812e-06
GC_6_81 b_6 NI_6 NS_81 0 9.1430448940644754e-02
GC_6_82 b_6 NI_6 NS_82 0 2.3325334000894949e-04
GC_6_83 b_6 NI_6 NS_83 0 4.5291254877709297e-03
GC_6_84 b_6 NI_6 NS_84 0 3.5032276061549786e-04
GC_6_85 b_6 NI_6 NS_85 0 1.4512785851848183e-04
GC_6_86 b_6 NI_6 NS_86 0 7.0835260448179471e-05
GC_6_87 b_6 NI_6 NS_87 0 1.5109990897162236e-05
GC_6_88 b_6 NI_6 NS_88 0 -3.3782792006033493e-05
GC_6_89 b_6 NI_6 NS_89 0 -1.4744945996405065e-03
GC_6_90 b_6 NI_6 NS_90 0 -3.6303311646598152e-04
GC_6_91 b_6 NI_6 NS_91 0 5.8194136059597560e-04
GC_6_92 b_6 NI_6 NS_92 0 1.7168631076695820e-04
GC_6_93 b_6 NI_6 NS_93 0 -3.9519384814062225e-03
GC_6_94 b_6 NI_6 NS_94 0 5.3090093183472923e-04
GC_6_95 b_6 NI_6 NS_95 0 -1.7492762665439044e-06
GC_6_96 b_6 NI_6 NS_96 0 1.9427469494851964e-05
GC_6_97 b_6 NI_6 NS_97 0 -1.5866327273170136e-05
GC_6_98 b_6 NI_6 NS_98 0 5.9538163262153496e-05
GC_6_99 b_6 NI_6 NS_99 0 1.9355124729647526e-05
GC_6_100 b_6 NI_6 NS_100 0 1.6537158097376672e-06
GC_6_101 b_6 NI_6 NS_101 0 2.3725013150087189e+00
GC_6_102 b_6 NI_6 NS_102 0 -2.3529914055410894e-03
GC_6_103 b_6 NI_6 NS_103 0 -4.3337863014480338e-02
GC_6_104 b_6 NI_6 NS_104 0 -7.0909611232593218e-04
GC_6_105 b_6 NI_6 NS_105 0 7.4745870193691292e-05
GC_6_106 b_6 NI_6 NS_106 0 5.6379977606140442e-06
GC_6_107 b_6 NI_6 NS_107 0 -2.9620769519109474e-06
GC_6_108 b_6 NI_6 NS_108 0 3.5471220234866541e-07
GC_6_109 b_6 NI_6 NS_109 0 -3.1940041053097057e-02
GC_6_110 b_6 NI_6 NS_110 0 -1.6721787351989825e-02
GC_6_111 b_6 NI_6 NS_111 0 -3.9221215898454509e-03
GC_6_112 b_6 NI_6 NS_112 0 -2.6064321119397037e-03
GC_6_113 b_6 NI_6 NS_113 0 -1.6275133221508312e-01
GC_6_114 b_6 NI_6 NS_114 0 -1.1742970173450756e-02
GC_6_115 b_6 NI_6 NS_115 0 -1.2589598687042460e-04
GC_6_116 b_6 NI_6 NS_116 0 6.8416099859741077e-04
GC_6_117 b_6 NI_6 NS_117 0 -3.6747007581250989e-06
GC_6_118 b_6 NI_6 NS_118 0 6.8490369252296914e-05
GC_6_119 b_6 NI_6 NS_119 0 -5.2799019884625478e-06
GC_6_120 b_6 NI_6 NS_120 0 -1.4168981548034849e-05
GC_6_121 b_6 NI_6 NS_121 0 5.5048952675224228e-01
GC_6_122 b_6 NI_6 NS_122 0 7.0524147836803584e-04
GC_6_123 b_6 NI_6 NS_123 0 1.0893821098665770e-02
GC_6_124 b_6 NI_6 NS_124 0 -5.3992416700256217e-04
GC_6_125 b_6 NI_6 NS_125 0 -7.8664339658541775e-05
GC_6_126 b_6 NI_6 NS_126 0 -6.7769589887046159e-05
GC_6_127 b_6 NI_6 NS_127 0 -9.9347555051284424e-06
GC_6_128 b_6 NI_6 NS_128 0 2.6965993234169759e-05
GC_6_129 b_6 NI_6 NS_129 0 3.9770484139079430e-04
GC_6_130 b_6 NI_6 NS_130 0 -5.7798535916710706e-05
GC_6_131 b_6 NI_6 NS_131 0 -1.3568429892980857e-04
GC_6_132 b_6 NI_6 NS_132 0 -9.7892112880723016e-05
GC_6_133 b_6 NI_6 NS_133 0 -8.9990774606124885e-03
GC_6_134 b_6 NI_6 NS_134 0 9.4645185937274057e-04
GC_6_135 b_6 NI_6 NS_135 0 -9.5897313215591504e-05
GC_6_136 b_6 NI_6 NS_136 0 1.1712323010861083e-04
GC_6_137 b_6 NI_6 NS_137 0 9.7546939799315366e-06
GC_6_138 b_6 NI_6 NS_138 0 -8.0347792242648229e-05
GC_6_139 b_6 NI_6 NS_139 0 -1.7315620985353680e-05
GC_6_140 b_6 NI_6 NS_140 0 2.0848547309562820e-06
GD_6_1 b_6 NI_6 NA_1 0 -4.0477523691983291e-02
GD_6_2 b_6 NI_6 NA_2 0 3.9278629812642936e-04
GD_6_3 b_6 NI_6 NA_3 0 -5.8443931552179376e-02
GD_6_4 b_6 NI_6 NA_4 0 -5.8539741542289345e-02
GD_6_5 b_6 NI_6 NA_5 0 -5.7847712009665014e-02
GD_6_6 b_6 NI_6 NA_6 0 4.8272649820697273e+00
GD_6_7 b_6 NI_6 NA_7 0 -3.5014044411525896e-01
*
* Port 7
VI_7 a_7 NI_7 0
RI_7 NI_7 b_7 1.0000000000000001e-01
GC_7_1 b_7 NI_7 NS_1 0 1.9029178770755464e-02
GC_7_2 b_7 NI_7 NS_2 0 -1.5385231283857111e-04
GC_7_3 b_7 NI_7 NS_3 0 -2.3606469579520624e-03
GC_7_4 b_7 NI_7 NS_4 0 4.2389355133429498e-03
GC_7_5 b_7 NI_7 NS_5 0 -1.6791595810681027e-03
GC_7_6 b_7 NI_7 NS_6 0 2.9148110524437334e-04
GC_7_7 b_7 NI_7 NS_7 0 5.4038389144946789e-05
GC_7_8 b_7 NI_7 NS_8 0 -1.2566566091513201e-04
GC_7_9 b_7 NI_7 NS_9 0 3.0013520579206237e-05
GC_7_10 b_7 NI_7 NS_10 0 6.6197448831396941e-06
GC_7_11 b_7 NI_7 NS_11 0 4.1607730819360835e-05
GC_7_12 b_7 NI_7 NS_12 0 1.1075871214363996e-05
GC_7_13 b_7 NI_7 NS_13 0 -5.6473698902611571e-04
GC_7_14 b_7 NI_7 NS_14 0 1.3264079027705493e-04
GC_7_15 b_7 NI_7 NS_15 0 -6.3715107037904091e-06
GC_7_16 b_7 NI_7 NS_16 0 9.2905962521683469e-06
GC_7_17 b_7 NI_7 NS_17 0 1.6208918975322279e-04
GC_7_18 b_7 NI_7 NS_18 0 2.9037983350355069e-04
GC_7_19 b_7 NI_7 NS_19 0 3.8814645053087501e-05
GC_7_20 b_7 NI_7 NS_20 0 -1.6037705359613934e-06
GC_7_21 b_7 NI_7 NS_21 0 2.1026790676758654e-03
GC_7_22 b_7 NI_7 NS_22 0 -5.5625631435494390e-05
GC_7_23 b_7 NI_7 NS_23 0 -1.1908642905997069e-03
GC_7_24 b_7 NI_7 NS_24 0 5.7068782034879395e-04
GC_7_25 b_7 NI_7 NS_25 0 9.3169891388192446e-04
GC_7_26 b_7 NI_7 NS_26 0 -2.9724822899944836e-05
GC_7_27 b_7 NI_7 NS_27 0 -1.0212840216357881e-07
GC_7_28 b_7 NI_7 NS_28 0 1.0782196225787534e-05
GC_7_29 b_7 NI_7 NS_29 0 2.3272369424396916e-05
GC_7_30 b_7 NI_7 NS_30 0 5.2505835388117527e-06
GC_7_31 b_7 NI_7 NS_31 0 -3.5620989006667457e-05
GC_7_32 b_7 NI_7 NS_32 0 -1.1054522158186602e-05
GC_7_33 b_7 NI_7 NS_33 0 -2.3634912315861621e-04
GC_7_34 b_7 NI_7 NS_34 0 9.4278717551639059e-05
GC_7_35 b_7 NI_7 NS_35 0 -2.0115668964735381e-07
GC_7_36 b_7 NI_7 NS_36 0 3.7896064884161078e-06
GC_7_37 b_7 NI_7 NS_37 0 -1.2358290136466629e-05
GC_7_38 b_7 NI_7 NS_38 0 -1.6332787694551054e-05
GC_7_39 b_7 NI_7 NS_39 0 -4.4167483240769986e-06
GC_7_40 b_7 NI_7 NS_40 0 -2.9380054528072829e-06
GC_7_41 b_7 NI_7 NS_41 0 1.9572627452564939e-02
GC_7_42 b_7 NI_7 NS_42 0 -9.0518399355466153e-05
GC_7_43 b_7 NI_7 NS_43 0 -1.6891809952636998e-03
GC_7_44 b_7 NI_7 NS_44 0 2.0446448286217497e-03
GC_7_45 b_7 NI_7 NS_45 0 -1.2008616554156082e-05
GC_7_46 b_7 NI_7 NS_46 0 6.8694571868391810e-05
GC_7_47 b_7 NI_7 NS_47 0 1.2443909619958119e-05
GC_7_48 b_7 NI_7 NS_48 0 -2.7148791744478300e-05
GC_7_49 b_7 NI_7 NS_49 0 2.4995756412146264e-05
GC_7_50 b_7 NI_7 NS_50 0 5.1653388326346798e-06
GC_7_51 b_7 NI_7 NS_51 0 -4.1952340090624839e-05
GC_7_52 b_7 NI_7 NS_52 0 -1.2335965308405476e-05
GC_7_53 b_7 NI_7 NS_53 0 -2.4517788467304566e-04
GC_7_54 b_7 NI_7 NS_54 0 1.1796665822988427e-04
GC_7_55 b_7 NI_7 NS_55 0 4.2572380076719037e-08
GC_7_56 b_7 NI_7 NS_56 0 4.3646242381706379e-06
GC_7_57 b_7 NI_7 NS_57 0 2.2953072983953599e-05
GC_7_58 b_7 NI_7 NS_58 0 8.1523917667534286e-05
GC_7_59 b_7 NI_7 NS_59 0 1.2385680840129635e-05
GC_7_60 b_7 NI_7 NS_60 0 -1.9477449391566385e-06
GC_7_61 b_7 NI_7 NS_61 0 3.7258824442062431e-02
GC_7_62 b_7 NI_7 NS_62 0 -5.7416808948478225e-05
GC_7_63 b_7 NI_7 NS_63 0 -1.2059496672899956e-03
GC_7_64 b_7 NI_7 NS_64 0 1.5991883249160007e-03
GC_7_65 b_7 NI_7 NS_65 0 3.1124453908692350e-04
GC_7_66 b_7 NI_7 NS_66 0 3.8558590114100508e-05
GC_7_67 b_7 NI_7 NS_67 0 8.7976974470586911e-06
GC_7_68 b_7 NI_7 NS_68 0 -1.7601772206349506e-05
GC_7_69 b_7 NI_7 NS_69 0 -3.8973023650943909e-05
GC_7_70 b_7 NI_7 NS_70 0 -4.8529744304759713e-06
GC_7_71 b_7 NI_7 NS_71 0 -2.1096478360744936e-05
GC_7_72 b_7 NI_7 NS_72 0 -8.2825402361677563e-06
GC_7_73 b_7 NI_7 NS_73 0 -3.1725287800899555e-04
GC_7_74 b_7 NI_7 NS_74 0 8.2351202221541553e-05
GC_7_75 b_7 NI_7 NS_75 0 -2.2130538569624267e-06
GC_7_76 b_7 NI_7 NS_76 0 4.6786706095958845e-06
GC_7_77 b_7 NI_7 NS_77 0 -3.0055213268807070e-05
GC_7_78 b_7 NI_7 NS_78 0 5.0846022430689658e-05
GC_7_79 b_7 NI_7 NS_79 0 1.1336241635470970e-05
GC_7_80 b_7 NI_7 NS_80 0 4.7369136385181707e-07
GC_7_81 b_7 NI_7 NS_81 0 1.4049076480680874e-02
GC_7_82 b_7 NI_7 NS_82 0 -4.6461403082938461e-05
GC_7_83 b_7 NI_7 NS_83 0 -1.1045204655880617e-03
GC_7_84 b_7 NI_7 NS_84 0 4.4903781420277243e-04
GC_7_85 b_7 NI_7 NS_85 0 9.1385984593493283e-04
GC_7_86 b_7 NI_7 NS_86 0 4.5179481131550357e-06
GC_7_87 b_7 NI_7 NS_87 0 9.3414027101718172e-06
GC_7_88 b_7 NI_7 NS_88 0 -9.8746727739594443e-06
GC_7_89 b_7 NI_7 NS_89 0 1.8525358302495641e-05
GC_7_90 b_7 NI_7 NS_90 0 -4.7614944138842787e-06
GC_7_91 b_7 NI_7 NS_91 0 2.0568655369277754e-05
GC_7_92 b_7 NI_7 NS_92 0 5.6132058817885974e-06
GC_7_93 b_7 NI_7 NS_93 0 -2.1064892893259046e-04
GC_7_94 b_7 NI_7 NS_94 0 6.7024159830907462e-05
GC_7_95 b_7 NI_7 NS_95 0 -2.3989945726948529e-06
GC_7_96 b_7 NI_7 NS_96 0 3.5615852879957008e-06
GC_7_97 b_7 NI_7 NS_97 0 1.6768961041578855e-06
GC_7_98 b_7 NI_7 NS_98 0 -4.7805353818183741e-06
GC_7_99 b_7 NI_7 NS_99 0 -9.7655190876824187e-07
GC_7_100 b_7 NI_7 NS_100 0 -2.4759347417813168e-06
GC_7_101 b_7 NI_7 NS_101 0 5.5048952675224228e-01
GC_7_102 b_7 NI_7 NS_102 0 7.0524147836803584e-04
GC_7_103 b_7 NI_7 NS_103 0 1.0893821098665770e-02
GC_7_104 b_7 NI_7 NS_104 0 -5.3992416700256217e-04
GC_7_105 b_7 NI_7 NS_105 0 -7.8664339658541775e-05
GC_7_106 b_7 NI_7 NS_106 0 -6.7769589887046159e-05
GC_7_107 b_7 NI_7 NS_107 0 -9.9347555051284424e-06
GC_7_108 b_7 NI_7 NS_108 0 2.6965993234169759e-05
GC_7_109 b_7 NI_7 NS_109 0 3.9770484139079430e-04
GC_7_110 b_7 NI_7 NS_110 0 -5.7798535916710706e-05
GC_7_111 b_7 NI_7 NS_111 0 -1.3568429892980857e-04
GC_7_112 b_7 NI_7 NS_112 0 -9.7892112880723016e-05
GC_7_113 b_7 NI_7 NS_113 0 -8.9990774606124885e-03
GC_7_114 b_7 NI_7 NS_114 0 9.4645185937274057e-04
GC_7_115 b_7 NI_7 NS_115 0 -9.5897313215591504e-05
GC_7_116 b_7 NI_7 NS_116 0 1.1712323010861083e-04
GC_7_117 b_7 NI_7 NS_117 0 9.7546939799315366e-06
GC_7_118 b_7 NI_7 NS_118 0 -8.0347792242648229e-05
GC_7_119 b_7 NI_7 NS_119 0 -1.7315620985353680e-05
GC_7_120 b_7 NI_7 NS_120 0 2.0848547309562820e-06
GC_7_121 b_7 NI_7 NS_121 0 1.4457801729726236e+00
GC_7_122 b_7 NI_7 NS_122 0 -4.7245369267710830e-05
GC_7_123 b_7 NI_7 NS_123 0 -3.4115981331838212e-03
GC_7_124 b_7 NI_7 NS_124 0 -8.1132706931915134e-03
GC_7_125 b_7 NI_7 NS_125 0 -7.3092300963830206e-04
GC_7_126 b_7 NI_7 NS_126 0 -1.9422322931093251e-04
GC_7_127 b_7 NI_7 NS_127 0 -4.5417303590605626e-05
GC_7_128 b_7 NI_7 NS_128 0 8.2119253580543747e-05
GC_7_129 b_7 NI_7 NS_129 0 -1.4230504718113179e-04
GC_7_130 b_7 NI_7 NS_130 0 -2.8343273967033488e-04
GC_7_131 b_7 NI_7 NS_131 0 1.1921097284737041e-05
GC_7_132 b_7 NI_7 NS_132 0 -1.1937255515383702e-05
GC_7_133 b_7 NI_7 NS_133 0 -3.2551142320527687e-04
GC_7_134 b_7 NI_7 NS_134 0 1.5653965573555320e-04
GC_7_135 b_7 NI_7 NS_135 0 -2.4108162234784536e-05
GC_7_136 b_7 NI_7 NS_136 0 -4.6308330542454807e-07
GC_7_137 b_7 NI_7 NS_137 0 -9.8567904672910376e-05
GC_7_138 b_7 NI_7 NS_138 0 -2.1155609598533880e-04
GC_7_139 b_7 NI_7 NS_139 0 -2.8830863565815675e-05
GC_7_140 b_7 NI_7 NS_140 0 7.7825230485930893e-06
GD_7_1 b_7 NI_7 NA_1 0 -1.1803018808171289e-02
GD_7_2 b_7 NI_7 NA_2 0 -1.1324206618523827e-03
GD_7_3 b_7 NI_7 NA_3 0 -1.2220400485516042e-02
GD_7_4 b_7 NI_7 NA_4 0 -2.3965622995677154e-02
GD_7_5 b_7 NI_7 NA_5 0 -9.0309340383733713e-03
GD_7_6 b_7 NI_7 NA_6 0 -3.5014044411525896e-01
GD_7_7 b_7 NI_7 NA_7 0 5.3827266664980460e+00
*
******************************************

********************************
* Synthesis of impinging waves *
********************************

* Impinging wave, port 1
RA_1 NA_1 0 1.5811388300841897e-01
FA_1 0 NA_1 VI_1 1.0
GA_1 0 NA_1 a_1 b_1 1.0000000000000000e+01
*
* Impinging wave, port 2
RA_2 NA_2 0 1.5811388300841897e-01
FA_2 0 NA_2 VI_2 1.0
GA_2 0 NA_2 a_2 b_2 1.0000000000000000e+01
*
* Impinging wave, port 3
RA_3 NA_3 0 1.5811388300841897e-01
FA_3 0 NA_3 VI_3 1.0
GA_3 0 NA_3 a_3 b_3 1.0000000000000000e+01
*
* Impinging wave, port 4
RA_4 NA_4 0 1.5811388300841897e-01
FA_4 0 NA_4 VI_4 1.0
GA_4 0 NA_4 a_4 b_4 1.0000000000000000e+01
*
* Impinging wave, port 5
RA_5 NA_5 0 1.5811388300841897e-01
FA_5 0 NA_5 VI_5 1.0
GA_5 0 NA_5 a_5 b_5 1.0000000000000000e+01
*
* Impinging wave, port 6
RA_6 NA_6 0 1.5811388300841897e-01
FA_6 0 NA_6 VI_6 1.0
GA_6 0 NA_6 a_6 b_6 1.0000000000000000e+01
*
* Impinging wave, port 7
RA_7 NA_7 0 1.5811388300841897e-01
FA_7 0 NA_7 VI_7 1.0
GA_7 0 NA_7 a_7 b_7 1.0000000000000000e+01
*
********************************

***************************************
* Synthesis of real and complex poles *
***************************************

* Real pole n. 1
CS_1 NS_1 0 9.9999999999999998e-13
RS_1 NS_1 0 1.2480583795826172e+00
GS_1_1 0 NS_1 NA_1 0 5.1625830071143697e-01
*
* Real pole n. 2
CS_2 NS_2 0 9.9999999999999998e-13
RS_2 NS_2 0 1.6518871556908277e+02
GS_2_1 0 NS_2 NA_1 0 5.1625830071143697e-01
*
* Real pole n. 3
CS_3 NS_3 0 9.9999999999999998e-13
RS_3 NS_3 0 4.5028796339108089e+02
GS_3_1 0 NS_3 NA_1 0 5.1625830071143697e-01
*
* Real pole n. 4
CS_4 NS_4 0 9.9999999999999998e-13
RS_4 NS_4 0 1.8395869161892138e+03
GS_4_1 0 NS_4 NA_1 0 5.1625830071143697e-01
*
* Real pole n. 5
CS_5 NS_5 0 9.9999999999999998e-13
RS_5 NS_5 0 3.2027781699676912e+03
GS_5_1 0 NS_5 NA_1 0 5.1625830071143697e-01
*
* Real pole n. 6
CS_6 NS_6 0 9.9999999999999998e-13
RS_6 NS_6 0 1.4122373289449733e+04
GS_6_1 0 NS_6 NA_1 0 5.1625830071143697e-01
*
* Real pole n. 7
CS_7 NS_7 0 9.9999999999999998e-13
RS_7 NS_7 0 3.5915540116952019e+04
GS_7_1 0 NS_7 NA_1 0 5.1625830071143697e-01
*
* Real pole n. 8
CS_8 NS_8 0 9.9999999999999998e-13
RS_8 NS_8 0 2.8882532276243121e+04
GS_8_1 0 NS_8 NA_1 0 5.1625830071143697e-01
*
* Complex pair n. 9/10
CS_9 NS_9 0 9.9999999999999998e-13
CS_10 NS_10 0 9.9999999999999998e-13
RS_9 NS_9 0 6.2516715196155496e+02
RS_10 NS_10 0 6.2516715196155508e+02
GL_9 0 NS_9 NS_10 0 6.5950671046758655e-02
GL_10 0 NS_10 NS_9 0 -6.5950671046758655e-02
GS_9_1 0 NS_9 NA_1 0 5.1625830071143697e-01
*
* Complex pair n. 11/12
CS_11 NS_11 0 9.9999999999999998e-13
CS_12 NS_12 0 9.9999999999999998e-13
RS_11 NS_11 0 1.1384801204426119e+03
RS_12 NS_12 0 1.1384801204426121e+03
GL_11 0 NS_11 NS_12 0 5.7075750434302228e-02
GL_12 0 NS_12 NS_11 0 -5.7075750434302228e-02
GS_11_1 0 NS_11 NA_1 0 5.1625830071143697e-01
*
* Complex pair n. 13/14
CS_13 NS_13 0 9.9999999999999998e-13
CS_14 NS_14 0 9.9999999999999998e-13
RS_13 NS_13 0 2.5557527877112244e+02
RS_14 NS_14 0 2.5557527877112241e+02
GL_13 0 NS_13 NS_14 0 4.6994083445698026e-02
GL_14 0 NS_14 NS_13 0 -4.6994083445698026e-02
GS_13_1 0 NS_13 NA_1 0 5.1625830071143697e-01
*
* Complex pair n. 15/16
CS_15 NS_15 0 9.9999999999999998e-13
CS_16 NS_16 0 9.9999999999999998e-13
RS_15 NS_15 0 2.1089278491116866e+03
RS_16 NS_16 0 2.1089278491116870e+03
GL_15 0 NS_15 NS_16 0 4.3233670020332605e-02
GL_16 0 NS_16 NS_15 0 -4.3233670020332605e-02
GS_15_1 0 NS_15 NA_1 0 5.1625830071143697e-01
*
* Complex pair n. 17/18
CS_17 NS_17 0 9.9999999999999998e-13
CS_18 NS_18 0 9.9999999999999998e-13
RS_17 NS_17 0 8.5443606110747587e+03
RS_18 NS_18 0 8.5443606110747587e+03
GL_17 0 NS_17 NS_18 0 1.1201774869613102e-04
GL_18 0 NS_18 NS_17 0 -1.1201774869613102e-04
GS_17_1 0 NS_17 NA_1 0 5.1625830071143697e-01
*
* Complex pair n. 19/20
CS_19 NS_19 0 9.9999999999999998e-13
CS_20 NS_20 0 9.9999999999999998e-13
RS_19 NS_19 0 2.5203699361211999e+04
RS_20 NS_20 0 2.5203699361211999e+04
GL_19 0 NS_19 NS_20 0 8.8697010895530986e-05
GL_20 0 NS_20 NS_19 0 -8.8697010895530986e-05
GS_19_1 0 NS_19 NA_1 0 5.1625830071143697e-01
*
* Real pole n. 21
CS_21 NS_21 0 9.9999999999999998e-13
RS_21 NS_21 0 1.2480583795826172e+00
GS_21_2 0 NS_21 NA_2 0 5.1625830071143697e-01
*
* Real pole n. 22
CS_22 NS_22 0 9.9999999999999998e-13
RS_22 NS_22 0 1.6518871556908277e+02
GS_22_2 0 NS_22 NA_2 0 5.1625830071143697e-01
*
* Real pole n. 23
CS_23 NS_23 0 9.9999999999999998e-13
RS_23 NS_23 0 4.5028796339108089e+02
GS_23_2 0 NS_23 NA_2 0 5.1625830071143697e-01
*
* Real pole n. 24
CS_24 NS_24 0 9.9999999999999998e-13
RS_24 NS_24 0 1.8395869161892138e+03
GS_24_2 0 NS_24 NA_2 0 5.1625830071143697e-01
*
* Real pole n. 25
CS_25 NS_25 0 9.9999999999999998e-13
RS_25 NS_25 0 3.2027781699676912e+03
GS_25_2 0 NS_25 NA_2 0 5.1625830071143697e-01
*
* Real pole n. 26
CS_26 NS_26 0 9.9999999999999998e-13
RS_26 NS_26 0 1.4122373289449733e+04
GS_26_2 0 NS_26 NA_2 0 5.1625830071143697e-01
*
* Real pole n. 27
CS_27 NS_27 0 9.9999999999999998e-13
RS_27 NS_27 0 3.5915540116952019e+04
GS_27_2 0 NS_27 NA_2 0 5.1625830071143697e-01
*
* Real pole n. 28
CS_28 NS_28 0 9.9999999999999998e-13
RS_28 NS_28 0 2.8882532276243121e+04
GS_28_2 0 NS_28 NA_2 0 5.1625830071143697e-01
*
* Complex pair n. 29/30
CS_29 NS_29 0 9.9999999999999998e-13
CS_30 NS_30 0 9.9999999999999998e-13
RS_29 NS_29 0 6.2516715196155496e+02
RS_30 NS_30 0 6.2516715196155508e+02
GL_29 0 NS_29 NS_30 0 6.5950671046758655e-02
GL_30 0 NS_30 NS_29 0 -6.5950671046758655e-02
GS_29_2 0 NS_29 NA_2 0 5.1625830071143697e-01
*
* Complex pair n. 31/32
CS_31 NS_31 0 9.9999999999999998e-13
CS_32 NS_32 0 9.9999999999999998e-13
RS_31 NS_31 0 1.1384801204426119e+03
RS_32 NS_32 0 1.1384801204426121e+03
GL_31 0 NS_31 NS_32 0 5.7075750434302228e-02
GL_32 0 NS_32 NS_31 0 -5.7075750434302228e-02
GS_31_2 0 NS_31 NA_2 0 5.1625830071143697e-01
*
* Complex pair n. 33/34
CS_33 NS_33 0 9.9999999999999998e-13
CS_34 NS_34 0 9.9999999999999998e-13
RS_33 NS_33 0 2.5557527877112244e+02
RS_34 NS_34 0 2.5557527877112241e+02
GL_33 0 NS_33 NS_34 0 4.6994083445698026e-02
GL_34 0 NS_34 NS_33 0 -4.6994083445698026e-02
GS_33_2 0 NS_33 NA_2 0 5.1625830071143697e-01
*
* Complex pair n. 35/36
CS_35 NS_35 0 9.9999999999999998e-13
CS_36 NS_36 0 9.9999999999999998e-13
RS_35 NS_35 0 2.1089278491116866e+03
RS_36 NS_36 0 2.1089278491116870e+03
GL_35 0 NS_35 NS_36 0 4.3233670020332605e-02
GL_36 0 NS_36 NS_35 0 -4.3233670020332605e-02
GS_35_2 0 NS_35 NA_2 0 5.1625830071143697e-01
*
* Complex pair n. 37/38
CS_37 NS_37 0 9.9999999999999998e-13
CS_38 NS_38 0 9.9999999999999998e-13
RS_37 NS_37 0 8.5443606110747587e+03
RS_38 NS_38 0 8.5443606110747587e+03
GL_37 0 NS_37 NS_38 0 1.1201774869613102e-04
GL_38 0 NS_38 NS_37 0 -1.1201774869613102e-04
GS_37_2 0 NS_37 NA_2 0 5.1625830071143697e-01
*
* Complex pair n. 39/40
CS_39 NS_39 0 9.9999999999999998e-13
CS_40 NS_40 0 9.9999999999999998e-13
RS_39 NS_39 0 2.5203699361211999e+04
RS_40 NS_40 0 2.5203699361211999e+04
GL_39 0 NS_39 NS_40 0 8.8697010895530986e-05
GL_40 0 NS_40 NS_39 0 -8.8697010895530986e-05
GS_39_2 0 NS_39 NA_2 0 5.1625830071143697e-01
*
* Real pole n. 41
CS_41 NS_41 0 9.9999999999999998e-13
RS_41 NS_41 0 1.2480583795826172e+00
GS_41_3 0 NS_41 NA_3 0 5.1625830071143697e-01
*
* Real pole n. 42
CS_42 NS_42 0 9.9999999999999998e-13
RS_42 NS_42 0 1.6518871556908277e+02
GS_42_3 0 NS_42 NA_3 0 5.1625830071143697e-01
*
* Real pole n. 43
CS_43 NS_43 0 9.9999999999999998e-13
RS_43 NS_43 0 4.5028796339108089e+02
GS_43_3 0 NS_43 NA_3 0 5.1625830071143697e-01
*
* Real pole n. 44
CS_44 NS_44 0 9.9999999999999998e-13
RS_44 NS_44 0 1.8395869161892138e+03
GS_44_3 0 NS_44 NA_3 0 5.1625830071143697e-01
*
* Real pole n. 45
CS_45 NS_45 0 9.9999999999999998e-13
RS_45 NS_45 0 3.2027781699676912e+03
GS_45_3 0 NS_45 NA_3 0 5.1625830071143697e-01
*
* Real pole n. 46
CS_46 NS_46 0 9.9999999999999998e-13
RS_46 NS_46 0 1.4122373289449733e+04
GS_46_3 0 NS_46 NA_3 0 5.1625830071143697e-01
*
* Real pole n. 47
CS_47 NS_47 0 9.9999999999999998e-13
RS_47 NS_47 0 3.5915540116952019e+04
GS_47_3 0 NS_47 NA_3 0 5.1625830071143697e-01
*
* Real pole n. 48
CS_48 NS_48 0 9.9999999999999998e-13
RS_48 NS_48 0 2.8882532276243121e+04
GS_48_3 0 NS_48 NA_3 0 5.1625830071143697e-01
*
* Complex pair n. 49/50
CS_49 NS_49 0 9.9999999999999998e-13
CS_50 NS_50 0 9.9999999999999998e-13
RS_49 NS_49 0 6.2516715196155496e+02
RS_50 NS_50 0 6.2516715196155508e+02
GL_49 0 NS_49 NS_50 0 6.5950671046758655e-02
GL_50 0 NS_50 NS_49 0 -6.5950671046758655e-02
GS_49_3 0 NS_49 NA_3 0 5.1625830071143697e-01
*
* Complex pair n. 51/52
CS_51 NS_51 0 9.9999999999999998e-13
CS_52 NS_52 0 9.9999999999999998e-13
RS_51 NS_51 0 1.1384801204426119e+03
RS_52 NS_52 0 1.1384801204426121e+03
GL_51 0 NS_51 NS_52 0 5.7075750434302228e-02
GL_52 0 NS_52 NS_51 0 -5.7075750434302228e-02
GS_51_3 0 NS_51 NA_3 0 5.1625830071143697e-01
*
* Complex pair n. 53/54
CS_53 NS_53 0 9.9999999999999998e-13
CS_54 NS_54 0 9.9999999999999998e-13
RS_53 NS_53 0 2.5557527877112244e+02
RS_54 NS_54 0 2.5557527877112241e+02
GL_53 0 NS_53 NS_54 0 4.6994083445698026e-02
GL_54 0 NS_54 NS_53 0 -4.6994083445698026e-02
GS_53_3 0 NS_53 NA_3 0 5.1625830071143697e-01
*
* Complex pair n. 55/56
CS_55 NS_55 0 9.9999999999999998e-13
CS_56 NS_56 0 9.9999999999999998e-13
RS_55 NS_55 0 2.1089278491116866e+03
RS_56 NS_56 0 2.1089278491116870e+03
GL_55 0 NS_55 NS_56 0 4.3233670020332605e-02
GL_56 0 NS_56 NS_55 0 -4.3233670020332605e-02
GS_55_3 0 NS_55 NA_3 0 5.1625830071143697e-01
*
* Complex pair n. 57/58
CS_57 NS_57 0 9.9999999999999998e-13
CS_58 NS_58 0 9.9999999999999998e-13
RS_57 NS_57 0 8.5443606110747587e+03
RS_58 NS_58 0 8.5443606110747587e+03
GL_57 0 NS_57 NS_58 0 1.1201774869613102e-04
GL_58 0 NS_58 NS_57 0 -1.1201774869613102e-04
GS_57_3 0 NS_57 NA_3 0 5.1625830071143697e-01
*
* Complex pair n. 59/60
CS_59 NS_59 0 9.9999999999999998e-13
CS_60 NS_60 0 9.9999999999999998e-13
RS_59 NS_59 0 2.5203699361211999e+04
RS_60 NS_60 0 2.5203699361211999e+04
GL_59 0 NS_59 NS_60 0 8.8697010895530986e-05
GL_60 0 NS_60 NS_59 0 -8.8697010895530986e-05
GS_59_3 0 NS_59 NA_3 0 5.1625830071143697e-01
*
* Real pole n. 61
CS_61 NS_61 0 9.9999999999999998e-13
RS_61 NS_61 0 1.2480583795826172e+00
GS_61_4 0 NS_61 NA_4 0 5.1625830071143697e-01
*
* Real pole n. 62
CS_62 NS_62 0 9.9999999999999998e-13
RS_62 NS_62 0 1.6518871556908277e+02
GS_62_4 0 NS_62 NA_4 0 5.1625830071143697e-01
*
* Real pole n. 63
CS_63 NS_63 0 9.9999999999999998e-13
RS_63 NS_63 0 4.5028796339108089e+02
GS_63_4 0 NS_63 NA_4 0 5.1625830071143697e-01
*
* Real pole n. 64
CS_64 NS_64 0 9.9999999999999998e-13
RS_64 NS_64 0 1.8395869161892138e+03
GS_64_4 0 NS_64 NA_4 0 5.1625830071143697e-01
*
* Real pole n. 65
CS_65 NS_65 0 9.9999999999999998e-13
RS_65 NS_65 0 3.2027781699676912e+03
GS_65_4 0 NS_65 NA_4 0 5.1625830071143697e-01
*
* Real pole n. 66
CS_66 NS_66 0 9.9999999999999998e-13
RS_66 NS_66 0 1.4122373289449733e+04
GS_66_4 0 NS_66 NA_4 0 5.1625830071143697e-01
*
* Real pole n. 67
CS_67 NS_67 0 9.9999999999999998e-13
RS_67 NS_67 0 3.5915540116952019e+04
GS_67_4 0 NS_67 NA_4 0 5.1625830071143697e-01
*
* Real pole n. 68
CS_68 NS_68 0 9.9999999999999998e-13
RS_68 NS_68 0 2.8882532276243121e+04
GS_68_4 0 NS_68 NA_4 0 5.1625830071143697e-01
*
* Complex pair n. 69/70
CS_69 NS_69 0 9.9999999999999998e-13
CS_70 NS_70 0 9.9999999999999998e-13
RS_69 NS_69 0 6.2516715196155496e+02
RS_70 NS_70 0 6.2516715196155508e+02
GL_69 0 NS_69 NS_70 0 6.5950671046758655e-02
GL_70 0 NS_70 NS_69 0 -6.5950671046758655e-02
GS_69_4 0 NS_69 NA_4 0 5.1625830071143697e-01
*
* Complex pair n. 71/72
CS_71 NS_71 0 9.9999999999999998e-13
CS_72 NS_72 0 9.9999999999999998e-13
RS_71 NS_71 0 1.1384801204426119e+03
RS_72 NS_72 0 1.1384801204426121e+03
GL_71 0 NS_71 NS_72 0 5.7075750434302228e-02
GL_72 0 NS_72 NS_71 0 -5.7075750434302228e-02
GS_71_4 0 NS_71 NA_4 0 5.1625830071143697e-01
*
* Complex pair n. 73/74
CS_73 NS_73 0 9.9999999999999998e-13
CS_74 NS_74 0 9.9999999999999998e-13
RS_73 NS_73 0 2.5557527877112244e+02
RS_74 NS_74 0 2.5557527877112241e+02
GL_73 0 NS_73 NS_74 0 4.6994083445698026e-02
GL_74 0 NS_74 NS_73 0 -4.6994083445698026e-02
GS_73_4 0 NS_73 NA_4 0 5.1625830071143697e-01
*
* Complex pair n. 75/76
CS_75 NS_75 0 9.9999999999999998e-13
CS_76 NS_76 0 9.9999999999999998e-13
RS_75 NS_75 0 2.1089278491116866e+03
RS_76 NS_76 0 2.1089278491116870e+03
GL_75 0 NS_75 NS_76 0 4.3233670020332605e-02
GL_76 0 NS_76 NS_75 0 -4.3233670020332605e-02
GS_75_4 0 NS_75 NA_4 0 5.1625830071143697e-01
*
* Complex pair n. 77/78
CS_77 NS_77 0 9.9999999999999998e-13
CS_78 NS_78 0 9.9999999999999998e-13
RS_77 NS_77 0 8.5443606110747587e+03
RS_78 NS_78 0 8.5443606110747587e+03
GL_77 0 NS_77 NS_78 0 1.1201774869613102e-04
GL_78 0 NS_78 NS_77 0 -1.1201774869613102e-04
GS_77_4 0 NS_77 NA_4 0 5.1625830071143697e-01
*
* Complex pair n. 79/80
CS_79 NS_79 0 9.9999999999999998e-13
CS_80 NS_80 0 9.9999999999999998e-13
RS_79 NS_79 0 2.5203699361211999e+04
RS_80 NS_80 0 2.5203699361211999e+04
GL_79 0 NS_79 NS_80 0 8.8697010895530986e-05
GL_80 0 NS_80 NS_79 0 -8.8697010895530986e-05
GS_79_4 0 NS_79 NA_4 0 5.1625830071143697e-01
*
* Real pole n. 81
CS_81 NS_81 0 9.9999999999999998e-13
RS_81 NS_81 0 1.2480583795826172e+00
GS_81_5 0 NS_81 NA_5 0 5.1625830071143697e-01
*
* Real pole n. 82
CS_82 NS_82 0 9.9999999999999998e-13
RS_82 NS_82 0 1.6518871556908277e+02
GS_82_5 0 NS_82 NA_5 0 5.1625830071143697e-01
*
* Real pole n. 83
CS_83 NS_83 0 9.9999999999999998e-13
RS_83 NS_83 0 4.5028796339108089e+02
GS_83_5 0 NS_83 NA_5 0 5.1625830071143697e-01
*
* Real pole n. 84
CS_84 NS_84 0 9.9999999999999998e-13
RS_84 NS_84 0 1.8395869161892138e+03
GS_84_5 0 NS_84 NA_5 0 5.1625830071143697e-01
*
* Real pole n. 85
CS_85 NS_85 0 9.9999999999999998e-13
RS_85 NS_85 0 3.2027781699676912e+03
GS_85_5 0 NS_85 NA_5 0 5.1625830071143697e-01
*
* Real pole n. 86
CS_86 NS_86 0 9.9999999999999998e-13
RS_86 NS_86 0 1.4122373289449733e+04
GS_86_5 0 NS_86 NA_5 0 5.1625830071143697e-01
*
* Real pole n. 87
CS_87 NS_87 0 9.9999999999999998e-13
RS_87 NS_87 0 3.5915540116952019e+04
GS_87_5 0 NS_87 NA_5 0 5.1625830071143697e-01
*
* Real pole n. 88
CS_88 NS_88 0 9.9999999999999998e-13
RS_88 NS_88 0 2.8882532276243121e+04
GS_88_5 0 NS_88 NA_5 0 5.1625830071143697e-01
*
* Complex pair n. 89/90
CS_89 NS_89 0 9.9999999999999998e-13
CS_90 NS_90 0 9.9999999999999998e-13
RS_89 NS_89 0 6.2516715196155496e+02
RS_90 NS_90 0 6.2516715196155508e+02
GL_89 0 NS_89 NS_90 0 6.5950671046758655e-02
GL_90 0 NS_90 NS_89 0 -6.5950671046758655e-02
GS_89_5 0 NS_89 NA_5 0 5.1625830071143697e-01
*
* Complex pair n. 91/92
CS_91 NS_91 0 9.9999999999999998e-13
CS_92 NS_92 0 9.9999999999999998e-13
RS_91 NS_91 0 1.1384801204426119e+03
RS_92 NS_92 0 1.1384801204426121e+03
GL_91 0 NS_91 NS_92 0 5.7075750434302228e-02
GL_92 0 NS_92 NS_91 0 -5.7075750434302228e-02
GS_91_5 0 NS_91 NA_5 0 5.1625830071143697e-01
*
* Complex pair n. 93/94
CS_93 NS_93 0 9.9999999999999998e-13
CS_94 NS_94 0 9.9999999999999998e-13
RS_93 NS_93 0 2.5557527877112244e+02
RS_94 NS_94 0 2.5557527877112241e+02
GL_93 0 NS_93 NS_94 0 4.6994083445698026e-02
GL_94 0 NS_94 NS_93 0 -4.6994083445698026e-02
GS_93_5 0 NS_93 NA_5 0 5.1625830071143697e-01
*
* Complex pair n. 95/96
CS_95 NS_95 0 9.9999999999999998e-13
CS_96 NS_96 0 9.9999999999999998e-13
RS_95 NS_95 0 2.1089278491116866e+03
RS_96 NS_96 0 2.1089278491116870e+03
GL_95 0 NS_95 NS_96 0 4.3233670020332605e-02
GL_96 0 NS_96 NS_95 0 -4.3233670020332605e-02
GS_95_5 0 NS_95 NA_5 0 5.1625830071143697e-01
*
* Complex pair n. 97/98
CS_97 NS_97 0 9.9999999999999998e-13
CS_98 NS_98 0 9.9999999999999998e-13
RS_97 NS_97 0 8.5443606110747587e+03
RS_98 NS_98 0 8.5443606110747587e+03
GL_97 0 NS_97 NS_98 0 1.1201774869613102e-04
GL_98 0 NS_98 NS_97 0 -1.1201774869613102e-04
GS_97_5 0 NS_97 NA_5 0 5.1625830071143697e-01
*
* Complex pair n. 99/100
CS_99 NS_99 0 9.9999999999999998e-13
CS_100 NS_100 0 9.9999999999999998e-13
RS_99 NS_99 0 2.5203699361211999e+04
RS_100 NS_100 0 2.5203699361211999e+04
GL_99 0 NS_99 NS_100 0 8.8697010895530986e-05
GL_100 0 NS_100 NS_99 0 -8.8697010895530986e-05
GS_99_5 0 NS_99 NA_5 0 5.1625830071143697e-01
*
* Real pole n. 101
CS_101 NS_101 0 9.9999999999999998e-13
RS_101 NS_101 0 1.2480583795826172e+00
GS_101_6 0 NS_101 NA_6 0 5.1625830071143697e-01
*
* Real pole n. 102
CS_102 NS_102 0 9.9999999999999998e-13
RS_102 NS_102 0 1.6518871556908277e+02
GS_102_6 0 NS_102 NA_6 0 5.1625830071143697e-01
*
* Real pole n. 103
CS_103 NS_103 0 9.9999999999999998e-13
RS_103 NS_103 0 4.5028796339108089e+02
GS_103_6 0 NS_103 NA_6 0 5.1625830071143697e-01
*
* Real pole n. 104
CS_104 NS_104 0 9.9999999999999998e-13
RS_104 NS_104 0 1.8395869161892138e+03
GS_104_6 0 NS_104 NA_6 0 5.1625830071143697e-01
*
* Real pole n. 105
CS_105 NS_105 0 9.9999999999999998e-13
RS_105 NS_105 0 3.2027781699676912e+03
GS_105_6 0 NS_105 NA_6 0 5.1625830071143697e-01
*
* Real pole n. 106
CS_106 NS_106 0 9.9999999999999998e-13
RS_106 NS_106 0 1.4122373289449733e+04
GS_106_6 0 NS_106 NA_6 0 5.1625830071143697e-01
*
* Real pole n. 107
CS_107 NS_107 0 9.9999999999999998e-13
RS_107 NS_107 0 3.5915540116952019e+04
GS_107_6 0 NS_107 NA_6 0 5.1625830071143697e-01
*
* Real pole n. 108
CS_108 NS_108 0 9.9999999999999998e-13
RS_108 NS_108 0 2.8882532276243121e+04
GS_108_6 0 NS_108 NA_6 0 5.1625830071143697e-01
*
* Complex pair n. 109/110
CS_109 NS_109 0 9.9999999999999998e-13
CS_110 NS_110 0 9.9999999999999998e-13
RS_109 NS_109 0 6.2516715196155496e+02
RS_110 NS_110 0 6.2516715196155508e+02
GL_109 0 NS_109 NS_110 0 6.5950671046758655e-02
GL_110 0 NS_110 NS_109 0 -6.5950671046758655e-02
GS_109_6 0 NS_109 NA_6 0 5.1625830071143697e-01
*
* Complex pair n. 111/112
CS_111 NS_111 0 9.9999999999999998e-13
CS_112 NS_112 0 9.9999999999999998e-13
RS_111 NS_111 0 1.1384801204426119e+03
RS_112 NS_112 0 1.1384801204426121e+03
GL_111 0 NS_111 NS_112 0 5.7075750434302228e-02
GL_112 0 NS_112 NS_111 0 -5.7075750434302228e-02
GS_111_6 0 NS_111 NA_6 0 5.1625830071143697e-01
*
* Complex pair n. 113/114
CS_113 NS_113 0 9.9999999999999998e-13
CS_114 NS_114 0 9.9999999999999998e-13
RS_113 NS_113 0 2.5557527877112244e+02
RS_114 NS_114 0 2.5557527877112241e+02
GL_113 0 NS_113 NS_114 0 4.6994083445698026e-02
GL_114 0 NS_114 NS_113 0 -4.6994083445698026e-02
GS_113_6 0 NS_113 NA_6 0 5.1625830071143697e-01
*
* Complex pair n. 115/116
CS_115 NS_115 0 9.9999999999999998e-13
CS_116 NS_116 0 9.9999999999999998e-13
RS_115 NS_115 0 2.1089278491116866e+03
RS_116 NS_116 0 2.1089278491116870e+03
GL_115 0 NS_115 NS_116 0 4.3233670020332605e-02
GL_116 0 NS_116 NS_115 0 -4.3233670020332605e-02
GS_115_6 0 NS_115 NA_6 0 5.1625830071143697e-01
*
* Complex pair n. 117/118
CS_117 NS_117 0 9.9999999999999998e-13
CS_118 NS_118 0 9.9999999999999998e-13
RS_117 NS_117 0 8.5443606110747587e+03
RS_118 NS_118 0 8.5443606110747587e+03
GL_117 0 NS_117 NS_118 0 1.1201774869613102e-04
GL_118 0 NS_118 NS_117 0 -1.1201774869613102e-04
GS_117_6 0 NS_117 NA_6 0 5.1625830071143697e-01
*
* Complex pair n. 119/120
CS_119 NS_119 0 9.9999999999999998e-13
CS_120 NS_120 0 9.9999999999999998e-13
RS_119 NS_119 0 2.5203699361211999e+04
RS_120 NS_120 0 2.5203699361211999e+04
GL_119 0 NS_119 NS_120 0 8.8697010895530986e-05
GL_120 0 NS_120 NS_119 0 -8.8697010895530986e-05
GS_119_6 0 NS_119 NA_6 0 5.1625830071143697e-01
*
* Real pole n. 121
CS_121 NS_121 0 9.9999999999999998e-13
RS_121 NS_121 0 1.2480583795826172e+00
GS_121_7 0 NS_121 NA_7 0 5.1625830071143697e-01
*
* Real pole n. 122
CS_122 NS_122 0 9.9999999999999998e-13
RS_122 NS_122 0 1.6518871556908277e+02
GS_122_7 0 NS_122 NA_7 0 5.1625830071143697e-01
*
* Real pole n. 123
CS_123 NS_123 0 9.9999999999999998e-13
RS_123 NS_123 0 4.5028796339108089e+02
GS_123_7 0 NS_123 NA_7 0 5.1625830071143697e-01
*
* Real pole n. 124
CS_124 NS_124 0 9.9999999999999998e-13
RS_124 NS_124 0 1.8395869161892138e+03
GS_124_7 0 NS_124 NA_7 0 5.1625830071143697e-01
*
* Real pole n. 125
CS_125 NS_125 0 9.9999999999999998e-13
RS_125 NS_125 0 3.2027781699676912e+03
GS_125_7 0 NS_125 NA_7 0 5.1625830071143697e-01
*
* Real pole n. 126
CS_126 NS_126 0 9.9999999999999998e-13
RS_126 NS_126 0 1.4122373289449733e+04
GS_126_7 0 NS_126 NA_7 0 5.1625830071143697e-01
*
* Real pole n. 127
CS_127 NS_127 0 9.9999999999999998e-13
RS_127 NS_127 0 3.5915540116952019e+04
GS_127_7 0 NS_127 NA_7 0 5.1625830071143697e-01
*
* Real pole n. 128
CS_128 NS_128 0 9.9999999999999998e-13
RS_128 NS_128 0 2.8882532276243121e+04
GS_128_7 0 NS_128 NA_7 0 5.1625830071143697e-01
*
* Complex pair n. 129/130
CS_129 NS_129 0 9.9999999999999998e-13
CS_130 NS_130 0 9.9999999999999998e-13
RS_129 NS_129 0 6.2516715196155496e+02
RS_130 NS_130 0 6.2516715196155508e+02
GL_129 0 NS_129 NS_130 0 6.5950671046758655e-02
GL_130 0 NS_130 NS_129 0 -6.5950671046758655e-02
GS_129_7 0 NS_129 NA_7 0 5.1625830071143697e-01
*
* Complex pair n. 131/132
CS_131 NS_131 0 9.9999999999999998e-13
CS_132 NS_132 0 9.9999999999999998e-13
RS_131 NS_131 0 1.1384801204426119e+03
RS_132 NS_132 0 1.1384801204426121e+03
GL_131 0 NS_131 NS_132 0 5.7075750434302228e-02
GL_132 0 NS_132 NS_131 0 -5.7075750434302228e-02
GS_131_7 0 NS_131 NA_7 0 5.1625830071143697e-01
*
* Complex pair n. 133/134
CS_133 NS_133 0 9.9999999999999998e-13
CS_134 NS_134 0 9.9999999999999998e-13
RS_133 NS_133 0 2.5557527877112244e+02
RS_134 NS_134 0 2.5557527877112241e+02
GL_133 0 NS_133 NS_134 0 4.6994083445698026e-02
GL_134 0 NS_134 NS_133 0 -4.6994083445698026e-02
GS_133_7 0 NS_133 NA_7 0 5.1625830071143697e-01
*
* Complex pair n. 135/136
CS_135 NS_135 0 9.9999999999999998e-13
CS_136 NS_136 0 9.9999999999999998e-13
RS_135 NS_135 0 2.1089278491116866e+03
RS_136 NS_136 0 2.1089278491116870e+03
GL_135 0 NS_135 NS_136 0 4.3233670020332605e-02
GL_136 0 NS_136 NS_135 0 -4.3233670020332605e-02
GS_135_7 0 NS_135 NA_7 0 5.1625830071143697e-01
*
* Complex pair n. 137/138
CS_137 NS_137 0 9.9999999999999998e-13
CS_138 NS_138 0 9.9999999999999998e-13
RS_137 NS_137 0 8.5443606110747587e+03
RS_138 NS_138 0 8.5443606110747587e+03
GL_137 0 NS_137 NS_138 0 1.1201774869613102e-04
GL_138 0 NS_138 NS_137 0 -1.1201774869613102e-04
GS_137_7 0 NS_137 NA_7 0 5.1625830071143697e-01
*
* Complex pair n. 139/140
CS_139 NS_139 0 9.9999999999999998e-13
CS_140 NS_140 0 9.9999999999999998e-13
RS_139 NS_139 0 2.5203699361211999e+04
RS_140 NS_140 0 2.5203699361211999e+04
GL_139 0 NS_139 NS_140 0 8.8697010895530986e-05
GL_140 0 NS_140 NS_139 0 -8.8697010895530986e-05
GS_139_7 0 NS_139 NA_7 0 5.1625830071143697e-01
*
******************************

.ends
*******************
* End of subcircuit
*******************
