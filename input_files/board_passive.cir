**********************************************************
** STATE-SPACE REALIZATION
** IN SPICE LANGUAGE
** This file is automatically generated
**********************************************************
** Created: 20-May-2023 by IdEM MP 12 (12.3.0)
**********************************************************
**
**********************************************************
** COMMENTS
**********************************************************
**
**  Touchstone file
**  Modal data exported
**  Port[1] = VRM
**  Port[2] = package
**
**********************************************************
**
**
**---------------------------
** Options Used in IdEM Flow
**---------------------------
**
** Fitting Options **
**
** Bandwidth: 5.0000e+09 Hz
** Order: [6 4 60]
** SplitType: none
** tol: 1.0000e-04
** DC Point: enforced
** Weights: relative
**    Alpha: 0.5
**    RelThreshold: 1e-10
**
**---------------------------
**
** Passivity Options **
**
** Alg: SOC+HAM
**    Max SOC it: 50
**    Max HAM it: 50
** Freq sampling: manual
**    In-band samples: 200
**    Off-band samples: 100
** DC Point: enforced
** Optimization method: Data based
** Weights: relative
**    Alpha: 0.5
**    Relative threshold: 1e-10
**
**---------------------------
**
** Netlist Options **
**
** Netlist format: SPICE standard
** Port reference: separate (floating)
** Resistor synthesis: standard
**
**---------------------------
**
**********************************************************
* NOTE:
* a_i  --> input node associated to the port i
* b_i  --> reference node associated to the port i
**********************************************************

***********************************
* Interface (ports specification) *
***********************************
.subckt board_passive
+  a_1 b_1
+  a_2 b_2
***********************************

******************************************
* Main circuit connected to output nodes *
******************************************

* Port 1
VI_1 a_1 NI_1 0
RI_1 NI_1 b_1 1.0000000000000001e-01
GC_1_1 b_1 NI_1 NS_1 0 9.5466791559216038e-05
GC_1_2 b_1 NI_1 NS_2 0 -1.0578262092690460e-04
GC_1_3 b_1 NI_1 NS_3 0 8.1742097882582916e-05
GC_1_4 b_1 NI_1 NS_4 0 -6.5100501097340937e-06
GC_1_5 b_1 NI_1 NS_5 0 5.4373494130947883e-07
GC_1_6 b_1 NI_1 NS_6 0 2.2335154405560571e-05
GC_1_7 b_1 NI_1 NS_7 0 -7.3380057300549386e-09
GC_1_8 b_1 NI_1 NS_8 0 6.4559226025737975e-09
GC_1_9 b_1 NI_1 NS_9 0 9.2952263203644269e-08
GC_1_10 b_1 NI_1 NS_10 0 -5.1646435668181422e-05
GC_1_11 b_1 NI_1 NS_11 0 6.5227329725146778e-04
GC_1_12 b_1 NI_1 NS_12 0 -9.2382702886329056e-03
GC_1_13 b_1 NI_1 NS_13 0 -1.3082724463311774e-04
GC_1_14 b_1 NI_1 NS_14 0 5.3117825088841951e-04
GC_1_15 b_1 NI_1 NS_15 0 3.9868201906416879e-06
GC_1_16 b_1 NI_1 NS_16 0 1.1150608956250270e-04
GC_1_17 b_1 NI_1 NS_17 0 5.5579068327259321e-05
GC_1_18 b_1 NI_1 NS_18 0 1.9350430039980518e-04
GC_1_19 b_1 NI_1 NS_19 0 9.2403486314614964e-05
GC_1_20 b_1 NI_1 NS_20 0 1.4061284838353652e-04
GC_1_21 b_1 NI_1 NS_21 0 5.3588724999021690e-05
GC_1_22 b_1 NI_1 NS_22 0 3.0775151656831453e-04
GC_1_23 b_1 NI_1 NS_23 0 -3.2939843088455975e-02
GC_1_24 b_1 NI_1 NS_24 0 1.7100164282459009e-03
GC_1_25 b_1 NI_1 NS_25 0 -1.4484516462514247e-03
GC_1_26 b_1 NI_1 NS_26 0 -1.7761621247066443e-03
GC_1_27 b_1 NI_1 NS_27 0 -3.3151112864208486e-05
GC_1_28 b_1 NI_1 NS_28 0 -1.1293327514265851e-04
GC_1_29 b_1 NI_1 NS_29 0 3.7146868173716450e-05
GC_1_30 b_1 NI_1 NS_30 0 1.9392676695455648e-05
GC_1_31 b_1 NI_1 NS_31 0 6.5231058159653416e-05
GC_1_32 b_1 NI_1 NS_32 0 -1.9879156582656242e-05
GC_1_33 b_1 NI_1 NS_33 0 2.4938054064720607e-05
GC_1_34 b_1 NI_1 NS_34 0 4.0903732588746730e-05
GC_1_35 b_1 NI_1 NS_35 0 -3.5192334240684271e-04
GC_1_36 b_1 NI_1 NS_36 0 2.9671050962572640e-05
GC_1_37 b_1 NI_1 NS_37 0 4.0769843583426131e-05
GC_1_38 b_1 NI_1 NS_38 0 -9.9520014901591784e-05
GC_1_39 b_1 NI_1 NS_39 0 -1.9411445887460727e-05
GC_1_40 b_1 NI_1 NS_40 0 3.8139263827661424e-06
GC_1_41 b_1 NI_1 NS_41 0 1.5533179776586047e-06
GC_1_42 b_1 NI_1 NS_42 0 -3.1799003956391280e-06
GC_1_43 b_1 NI_1 NS_43 0 3.5055454162071758e-07
GC_1_44 b_1 NI_1 NS_44 0 -1.4829762229913997e-06
GC_1_45 b_1 NI_1 NS_45 0 9.2011093460864733e-07
GC_1_46 b_1 NI_1 NS_46 0 -7.6801823569546717e-07
GC_1_47 b_1 NI_1 NS_47 0 3.4620483992402887e-07
GC_1_48 b_1 NI_1 NS_48 0 -6.8053252920385831e-07
GC_1_49 b_1 NI_1 NS_49 0 -6.4551746249014862e-08
GC_1_50 b_1 NI_1 NS_50 0 -2.3740216869400337e-07
GC_1_51 b_1 NI_1 NS_51 0 -7.3093284893175467e-08
GC_1_52 b_1 NI_1 NS_52 0 2.3001231340597735e-08
GC_1_53 b_1 NI_1 NS_53 0 -1.7426413164464830e-07
GC_1_54 b_1 NI_1 NS_54 0 -1.0137395003642662e-07
GC_1_55 b_1 NI_1 NS_55 0 -2.6588905676040588e-06
GC_1_56 b_1 NI_1 NS_56 0 -8.9901068734380528e-07
GC_1_57 b_1 NI_1 NS_57 0 -3.1954259108953105e-07
GC_1_58 b_1 NI_1 NS_58 0 1.6999364082754083e-06
GC_1_59 b_1 NI_1 NS_59 0 -9.3761064733288999e-07
GC_1_60 b_1 NI_1 NS_60 0 -4.6000210974918128e-07
GC_1_61 b_1 NI_1 NS_61 0 2.1899221881380957e-07
GC_1_62 b_1 NI_1 NS_62 0 -1.1237014871017639e-07
GC_1_63 b_1 NI_1 NS_63 0 -3.9095003295652152e-06
GC_1_64 b_1 NI_1 NS_64 0 3.3585204809366091e-06
GC_1_65 b_1 NI_1 NS_65 0 2.4132651565627162e-06
GC_1_66 b_1 NI_1 NS_66 0 1.5477686928052719e-06
GC_1_67 b_1 NI_1 NS_67 0 -6.3702667978887988e-06
GC_1_68 b_1 NI_1 NS_68 0 -9.0401754717001274e-05
GC_1_69 b_1 NI_1 NS_69 0 7.4112097828005502e-09
GC_1_70 b_1 NI_1 NS_70 0 -6.5510716652396794e-09
GC_1_71 b_1 NI_1 NS_71 0 3.8413390934767362e-08
GC_1_72 b_1 NI_1 NS_72 0 9.6905187629752292e-05
GC_1_73 b_1 NI_1 NS_73 0 -1.2691745004619886e-03
GC_1_74 b_1 NI_1 NS_74 0 -1.7166327308608604e-04
GC_1_75 b_1 NI_1 NS_75 0 2.6578042507225725e-04
GC_1_76 b_1 NI_1 NS_76 0 1.8682497115201478e-04
GC_1_77 b_1 NI_1 NS_77 0 8.5564240446357943e-06
GC_1_78 b_1 NI_1 NS_78 0 -1.8760949076581471e-05
GC_1_79 b_1 NI_1 NS_79 0 -2.0539901580174627e-05
GC_1_80 b_1 NI_1 NS_80 0 -2.0082282561192945e-05
GC_1_81 b_1 NI_1 NS_81 0 -6.2791765548415366e-05
GC_1_82 b_1 NI_1 NS_82 0 -6.3472899168742425e-05
GC_1_83 b_1 NI_1 NS_83 0 1.5752136868252088e-05
GC_1_84 b_1 NI_1 NS_84 0 4.0283688292418259e-05
GC_1_85 b_1 NI_1 NS_85 0 3.4799779673576801e-03
GC_1_86 b_1 NI_1 NS_86 0 9.1771472345250301e-04
GC_1_87 b_1 NI_1 NS_87 0 -2.9003347590272743e-03
GC_1_88 b_1 NI_1 NS_88 0 -1.0148710343078728e-03
GC_1_89 b_1 NI_1 NS_89 0 -3.9502238076040159e-04
GC_1_90 b_1 NI_1 NS_90 0 -9.9928249597798385e-05
GC_1_91 b_1 NI_1 NS_91 0 5.3539733661238027e-05
GC_1_92 b_1 NI_1 NS_92 0 1.6008647737841499e-05
GC_1_93 b_1 NI_1 NS_93 0 8.1210878706409383e-06
GC_1_94 b_1 NI_1 NS_94 0 -2.2621549338288534e-07
GC_1_95 b_1 NI_1 NS_95 0 -4.5657441204901273e-06
GC_1_96 b_1 NI_1 NS_96 0 -7.3626871092240296e-06
GC_1_97 b_1 NI_1 NS_97 0 1.6420120609300022e-05
GC_1_98 b_1 NI_1 NS_98 0 -7.6174322524890902e-06
GC_1_99 b_1 NI_1 NS_99 0 4.8524734426906755e-06
GC_1_100 b_1 NI_1 NS_100 0 -2.9137220973621089e-06
GC_1_101 b_1 NI_1 NS_101 0 6.5287743963911352e-06
GC_1_102 b_1 NI_1 NS_102 0 -1.1714956950755465e-06
GC_1_103 b_1 NI_1 NS_103 0 3.9952585133417848e-06
GC_1_104 b_1 NI_1 NS_104 0 -3.9541874720927186e-07
GC_1_105 b_1 NI_1 NS_105 0 1.1743826095876561e-06
GC_1_106 b_1 NI_1 NS_106 0 -3.2750357772010193e-07
GC_1_107 b_1 NI_1 NS_107 0 1.1540590738449026e-05
GC_1_108 b_1 NI_1 NS_108 0 9.1543793692426184e-07
GC_1_109 b_1 NI_1 NS_109 0 6.2422343661222010e-09
GC_1_110 b_1 NI_1 NS_110 0 -2.2496933535821199e-08
GC_1_111 b_1 NI_1 NS_111 0 3.4544752285928766e-08
GC_1_112 b_1 NI_1 NS_112 0 1.2205496260084334e-07
GC_1_113 b_1 NI_1 NS_113 0 1.2746974858065848e-07
GC_1_114 b_1 NI_1 NS_114 0 1.4689021214668844e-08
GC_1_115 b_1 NI_1 NS_115 0 9.1298564240426685e-08
GC_1_116 b_1 NI_1 NS_116 0 8.0176725011196097e-09
GC_1_117 b_1 NI_1 NS_117 0 -4.6024156526060441e-07
GC_1_118 b_1 NI_1 NS_118 0 -2.4911678145595568e-07
GC_1_119 b_1 NI_1 NS_119 0 -8.2553385749921641e-07
GC_1_120 b_1 NI_1 NS_120 0 -6.8583367995334813e-07
GC_1_121 b_1 NI_1 NS_121 0 -1.6668072684475040e-08
GC_1_122 b_1 NI_1 NS_122 0 -3.2295396147210971e-08
GC_1_123 b_1 NI_1 NS_123 0 9.0836635008655930e-08
GC_1_124 b_1 NI_1 NS_124 0 -7.5678928227961911e-07
GD_1_1 b_1 NI_1 NA_1 0 6.3162271182120948e+00
GD_1_2 b_1 NI_1 NA_2 0 3.7399315607582607e-04
*
* Port 2
VI_2 a_2 NI_2 0
RI_2 NI_2 b_2 1.0000000000000001e-01
GC_2_1 b_2 NI_2 NS_1 0 -3.9095003295652152e-06
GC_2_2 b_2 NI_2 NS_2 0 3.3585204809366091e-06
GC_2_3 b_2 NI_2 NS_3 0 2.4132651565627162e-06
GC_2_4 b_2 NI_2 NS_4 0 1.5477686928052719e-06
GC_2_5 b_2 NI_2 NS_5 0 -6.3702667978887988e-06
GC_2_6 b_2 NI_2 NS_6 0 -9.0401754717001274e-05
GC_2_7 b_2 NI_2 NS_7 0 7.4112097828005502e-09
GC_2_8 b_2 NI_2 NS_8 0 -6.5510716652396794e-09
GC_2_9 b_2 NI_2 NS_9 0 3.8413390934767362e-08
GC_2_10 b_2 NI_2 NS_10 0 9.6905187629752292e-05
GC_2_11 b_2 NI_2 NS_11 0 -1.2691745004619886e-03
GC_2_12 b_2 NI_2 NS_12 0 -1.7166327308608604e-04
GC_2_13 b_2 NI_2 NS_13 0 2.6578042507225725e-04
GC_2_14 b_2 NI_2 NS_14 0 1.8682497115201478e-04
GC_2_15 b_2 NI_2 NS_15 0 8.5564240446357943e-06
GC_2_16 b_2 NI_2 NS_16 0 -1.8760949076581471e-05
GC_2_17 b_2 NI_2 NS_17 0 -2.0539901580174627e-05
GC_2_18 b_2 NI_2 NS_18 0 -2.0082282561192945e-05
GC_2_19 b_2 NI_2 NS_19 0 -6.2791765548415366e-05
GC_2_20 b_2 NI_2 NS_20 0 -6.3472899168742425e-05
GC_2_21 b_2 NI_2 NS_21 0 1.5752136868252088e-05
GC_2_22 b_2 NI_2 NS_22 0 4.0283688292418259e-05
GC_2_23 b_2 NI_2 NS_23 0 3.4799779673576801e-03
GC_2_24 b_2 NI_2 NS_24 0 9.1771472345250301e-04
GC_2_25 b_2 NI_2 NS_25 0 -2.9003347590272743e-03
GC_2_26 b_2 NI_2 NS_26 0 -1.0148710343078728e-03
GC_2_27 b_2 NI_2 NS_27 0 -3.9502238076040159e-04
GC_2_28 b_2 NI_2 NS_28 0 -9.9928249597798385e-05
GC_2_29 b_2 NI_2 NS_29 0 5.3539733661238027e-05
GC_2_30 b_2 NI_2 NS_30 0 1.6008647737841499e-05
GC_2_31 b_2 NI_2 NS_31 0 8.1210878706409383e-06
GC_2_32 b_2 NI_2 NS_32 0 -2.2621549338288534e-07
GC_2_33 b_2 NI_2 NS_33 0 -4.5657441204901273e-06
GC_2_34 b_2 NI_2 NS_34 0 -7.3626871092240296e-06
GC_2_35 b_2 NI_2 NS_35 0 1.6420120609300022e-05
GC_2_36 b_2 NI_2 NS_36 0 -7.6174322524890902e-06
GC_2_37 b_2 NI_2 NS_37 0 4.8524734426906755e-06
GC_2_38 b_2 NI_2 NS_38 0 -2.9137220973621089e-06
GC_2_39 b_2 NI_2 NS_39 0 6.5287743963911352e-06
GC_2_40 b_2 NI_2 NS_40 0 -1.1714956950755465e-06
GC_2_41 b_2 NI_2 NS_41 0 3.9952585133417848e-06
GC_2_42 b_2 NI_2 NS_42 0 -3.9541874720927186e-07
GC_2_43 b_2 NI_2 NS_43 0 1.1743826095876561e-06
GC_2_44 b_2 NI_2 NS_44 0 -3.2750357772010193e-07
GC_2_45 b_2 NI_2 NS_45 0 1.1540590738449026e-05
GC_2_46 b_2 NI_2 NS_46 0 9.1543793692426184e-07
GC_2_47 b_2 NI_2 NS_47 0 6.2422343661222010e-09
GC_2_48 b_2 NI_2 NS_48 0 -2.2496933535821199e-08
GC_2_49 b_2 NI_2 NS_49 0 3.4544752285928766e-08
GC_2_50 b_2 NI_2 NS_50 0 1.2205496260084334e-07
GC_2_51 b_2 NI_2 NS_51 0 1.2746974858065848e-07
GC_2_52 b_2 NI_2 NS_52 0 1.4689021214668844e-08
GC_2_53 b_2 NI_2 NS_53 0 9.1298564240426685e-08
GC_2_54 b_2 NI_2 NS_54 0 8.0176725011196097e-09
GC_2_55 b_2 NI_2 NS_55 0 -4.6024156526060441e-07
GC_2_56 b_2 NI_2 NS_56 0 -2.4911678145595568e-07
GC_2_57 b_2 NI_2 NS_57 0 -8.2553385749921641e-07
GC_2_58 b_2 NI_2 NS_58 0 -6.8583367995334813e-07
GC_2_59 b_2 NI_2 NS_59 0 -1.6668072684475040e-08
GC_2_60 b_2 NI_2 NS_60 0 -3.2295396147210971e-08
GC_2_61 b_2 NI_2 NS_61 0 9.0836635008655930e-08
GC_2_62 b_2 NI_2 NS_62 0 -7.5678928227961911e-07
GC_2_63 b_2 NI_2 NS_63 0 -7.8822227959432414e-03
GC_2_64 b_2 NI_2 NS_64 0 -6.1919740953577738e-02
GC_2_65 b_2 NI_2 NS_65 0 -9.0583791770952937e-02
GC_2_66 b_2 NI_2 NS_66 0 -1.4609226709054960e-03
GC_2_67 b_2 NI_2 NS_67 0 5.9655381389506494e-05
GC_2_68 b_2 NI_2 NS_68 0 3.7395415039796840e-04
GC_2_69 b_2 NI_2 NS_69 0 -7.3809382747983911e-09
GC_2_70 b_2 NI_2 NS_70 0 6.5721176189637048e-09
GC_2_71 b_2 NI_2 NS_71 0 1.5183796062254553e-07
GC_2_72 b_2 NI_2 NS_72 0 -1.8424686636640171e-04
GC_2_73 b_2 NI_2 NS_73 0 -9.1773196139234001e-02
GC_2_74 b_2 NI_2 NS_74 0 -2.7813989421207214e-01
GC_2_75 b_2 NI_2 NS_75 0 1.3298492023177906e-02
GC_2_76 b_2 NI_2 NS_76 0 -2.5575808428408720e-03
GC_2_77 b_2 NI_2 NS_77 0 4.6852746803804739e-04
GC_2_78 b_2 NI_2 NS_78 0 1.6344310923641465e-03
GC_2_79 b_2 NI_2 NS_79 0 -1.5357770485669448e-03
GC_2_80 b_2 NI_2 NS_80 0 -7.9361836510553584e-03
GC_2_81 b_2 NI_2 NS_81 0 1.5443262670064466e-03
GC_2_82 b_2 NI_2 NS_82 0 -2.8954623855778632e-03
GC_2_83 b_2 NI_2 NS_83 0 -1.9058777746286729e-03
GC_2_84 b_2 NI_2 NS_84 0 -6.9986381074680195e-03
GC_2_85 b_2 NI_2 NS_85 0 -2.7303120155472266e-03
GC_2_86 b_2 NI_2 NS_86 0 1.3805796486846924e-03
GC_2_87 b_2 NI_2 NS_87 0 -2.0091673731206131e-02
GC_2_88 b_2 NI_2 NS_88 0 -5.9372480144560735e-03
GC_2_89 b_2 NI_2 NS_89 0 -3.6215044726365538e-03
GC_2_90 b_2 NI_2 NS_90 0 5.2953053617938031e-05
GC_2_91 b_2 NI_2 NS_91 0 -2.5580931375500819e-02
GC_2_92 b_2 NI_2 NS_92 0 -3.5767784228723518e-03
GC_2_93 b_2 NI_2 NS_93 0 -4.0318434577156876e-03
GC_2_94 b_2 NI_2 NS_94 0 -2.1497681112257485e-03
GC_2_95 b_2 NI_2 NS_95 0 -4.4519302636128171e-03
GC_2_96 b_2 NI_2 NS_96 0 -3.7274632312916868e-04
GC_2_97 b_2 NI_2 NS_97 0 -7.7243206351174475e-05
GC_2_98 b_2 NI_2 NS_98 0 -2.8945650293797930e-04
GC_2_99 b_2 NI_2 NS_99 0 -3.6745991486472626e-03
GC_2_100 b_2 NI_2 NS_100 0 -9.0831525016786714e-04
GC_2_101 b_2 NI_2 NS_101 0 -4.3954111218453273e-03
GC_2_102 b_2 NI_2 NS_102 0 4.5459653222501670e-04
GC_2_103 b_2 NI_2 NS_103 0 -2.1845170721369700e-03
GC_2_104 b_2 NI_2 NS_104 0 1.1875079331063253e-04
GC_2_105 b_2 NI_2 NS_105 0 -8.3829476424807092e-04
GC_2_106 b_2 NI_2 NS_106 0 -1.4993738173747046e-05
GC_2_107 b_2 NI_2 NS_107 0 -4.1316617166961757e-02
GC_2_108 b_2 NI_2 NS_108 0 -3.5508066690330231e-03
GC_2_109 b_2 NI_2 NS_109 0 -1.2003237384713960e-04
GC_2_110 b_2 NI_2 NS_110 0 3.1485112808740765e-04
GC_2_111 b_2 NI_2 NS_111 0 -4.8171035476399591e-03
GC_2_112 b_2 NI_2 NS_112 0 -1.2405753962822553e-03
GC_2_113 b_2 NI_2 NS_113 0 -3.8304458512176747e-04
GC_2_114 b_2 NI_2 NS_114 0 -1.7456456356736516e-04
GC_2_115 b_2 NI_2 NS_115 0 -3.4445111645708554e-05
GC_2_116 b_2 NI_2 NS_116 0 -1.3601346233281226e-05
GC_2_117 b_2 NI_2 NS_117 0 2.5815790845856307e-03
GC_2_118 b_2 NI_2 NS_118 0 -2.7071342132258757e-03
GC_2_119 b_2 NI_2 NS_119 0 1.5397714295683146e-03
GC_2_120 b_2 NI_2 NS_120 0 -3.5095622827572902e-03
GC_2_121 b_2 NI_2 NS_121 0 1.8655021553124583e-04
GC_2_122 b_2 NI_2 NS_122 0 2.7602659263843326e-05
GC_2_123 b_2 NI_2 NS_123 0 2.5562521452978867e-04
GC_2_124 b_2 NI_2 NS_124 0 3.1065308505724352e-05
GD_2_1 b_2 NI_2 NA_1 0 3.7399315607582607e-04
GD_2_2 b_2 NI_2 NA_2 0 6.0544675455033437e+00
*
******************************************

********************************
* Synthesis of impinging waves *
********************************

* Impinging wave, port 1
RA_1 NA_1 0 1.5811388300841897e-01
FA_1 0 NA_1 VI_1 1.0
GA_1 0 NA_1 a_1 b_1 1.0000000000000000e+01
*
* Impinging wave, port 2
RA_2 NA_2 0 1.5811388300841897e-01
FA_2 0 NA_2 VI_2 1.0
GA_2 0 NA_2 a_2 b_2 1.0000000000000000e+01
*
********************************

***************************************
* Synthesis of real and complex poles *
***************************************

* Real pole n. 1
CS_1 NS_1 0 9.9999999999999998e-13
RS_1 NS_1 0 2.6812382496167982e+02
GS_1_1 0 NS_1 NA_1 0 4.4004921040099176e-02
*
* Real pole n. 2
CS_2 NS_2 0 9.9999999999999998e-13
RS_2 NS_2 0 1.3994731188988526e+03
GS_2_1 0 NS_2 NA_1 0 4.4004921040099176e-02
*
* Real pole n. 3
CS_3 NS_3 0 9.9999999999999998e-13
RS_3 NS_3 0 2.2826790726153595e+03
GS_3_1 0 NS_3 NA_1 0 4.4004921040099176e-02
*
* Real pole n. 4
CS_4 NS_4 0 9.9999999999999998e-13
RS_4 NS_4 0 8.9038736282574646e+03
GS_4_1 0 NS_4 NA_1 0 4.4004921040099176e-02
*
* Real pole n. 5
CS_5 NS_5 0 9.9999999999999998e-13
RS_5 NS_5 0 8.1624030462346354e+05
GS_5_1 0 NS_5 NA_1 0 4.4004921040099176e-02
*
* Real pole n. 6
CS_6 NS_6 0 9.9999999999999998e-13
RS_6 NS_6 0 1.5686805607432274e+06
GS_6_1 0 NS_6 NA_1 0 4.4004921040099176e-02
*
* Real pole n. 7
CS_7 NS_7 0 9.9999999999999998e-13
RS_7 NS_7 0 7.4956827294422567e+08
GS_7_1 0 NS_7 NA_1 0 4.4004921040099176e-02
*
* Real pole n. 8
CS_8 NS_8 0 9.9999999999999998e-13
RS_8 NS_8 0 2.9819117004006445e+08
GS_8_1 0 NS_8 NA_1 0 4.4004921040099176e-02
*
* Real pole n. 9
CS_9 NS_9 0 9.9999999999999998e-13
RS_9 NS_9 0 5.8398553078453373e+06
GS_9_1 0 NS_9 NA_1 0 4.4004921040099176e-02
*
* Real pole n. 10
CS_10 NS_10 0 9.9999999999999998e-13
RS_10 NS_10 0 2.4450573444296578e+06
GS_10_1 0 NS_10 NA_1 0 4.4004921040099176e-02
*
* Complex pair n. 11/12
CS_11 NS_11 0 9.9999999999999998e-13
CS_12 NS_12 0 9.9999999999999998e-13
RS_11 NS_11 0 5.8489347765199994e+01
RS_12 NS_12 0 5.8489347765199994e+01
GL_11 0 NS_11 NS_12 0 3.0506948724049354e-02
GL_12 0 NS_12 NS_11 0 -3.0506948724049354e-02
GS_11_1 0 NS_11 NA_1 0 4.4004921040099176e-02
*
* Complex pair n. 13/14
CS_13 NS_13 0 9.9999999999999998e-13
CS_14 NS_14 0 9.9999999999999998e-13
RS_13 NS_13 0 7.9970336946000464e+02
RS_14 NS_14 0 7.9970336946000452e+02
GL_13 0 NS_13 NS_14 0 3.1496579383007282e-02
GL_14 0 NS_14 NS_13 0 -3.1496579383007282e-02
GS_13_1 0 NS_13 NA_1 0 4.4004921040099176e-02
*
* Complex pair n. 15/16
CS_15 NS_15 0 9.9999999999999998e-13
CS_16 NS_16 0 9.9999999999999998e-13
RS_15 NS_15 0 1.8036406617964012e+03
RS_16 NS_16 0 1.8036406617964012e+03
GL_15 0 NS_15 NS_16 0 3.0333145406357103e-02
GL_16 0 NS_16 NS_15 0 -3.0333145406357103e-02
GS_15_1 0 NS_15 NA_1 0 4.4004921040099176e-02
*
* Complex pair n. 17/18
CS_17 NS_17 0 9.9999999999999998e-13
CS_18 NS_18 0 9.9999999999999998e-13
RS_17 NS_17 0 1.4319660708934398e+03
RS_18 NS_18 0 1.4319660708934400e+03
GL_17 0 NS_17 NS_18 0 2.9535265241571747e-02
GL_18 0 NS_18 NS_17 0 -2.9535265241571747e-02
GS_17_1 0 NS_17 NA_1 0 4.4004921040099176e-02
*
* Complex pair n. 19/20
CS_19 NS_19 0 9.9999999999999998e-13
CS_20 NS_20 0 9.9999999999999998e-13
RS_19 NS_19 0 1.4182072682574346e+03
RS_20 NS_20 0 1.4182072682574344e+03
GL_19 0 NS_19 NS_20 0 2.8637997504011751e-02
GL_20 0 NS_20 NS_19 0 -2.8637997504011751e-02
GS_19_1 0 NS_19 NA_1 0 4.4004921040099176e-02
*
* Complex pair n. 21/22
CS_21 NS_21 0 9.9999999999999998e-13
CS_22 NS_22 0 9.9999999999999998e-13
RS_21 NS_21 0 1.1280382663726675e+03
RS_22 NS_22 0 1.1280382663726675e+03
GL_21 0 NS_21 NS_22 0 2.7322429360434351e-02
GL_22 0 NS_22 NS_21 0 -2.7322429360434351e-02
GS_21_1 0 NS_21 NA_1 0 4.4004921040099176e-02
*
* Complex pair n. 23/24
CS_23 NS_23 0 9.9999999999999998e-13
CS_24 NS_24 0 9.9999999999999998e-13
RS_23 NS_23 0 1.5126459944053822e+03
RS_24 NS_24 0 1.5126459944053822e+03
GL_23 0 NS_23 NS_24 0 2.5612783053065323e-02
GL_24 0 NS_24 NS_23 0 -2.5612783053065323e-02
GS_23_1 0 NS_23 NA_1 0 4.4004921040099176e-02
*
* Complex pair n. 25/26
CS_25 NS_25 0 9.9999999999999998e-13
CS_26 NS_26 0 9.9999999999999998e-13
RS_25 NS_25 0 1.5212465428239163e+03
RS_26 NS_26 0 1.5212465428239163e+03
GL_25 0 NS_25 NS_26 0 2.5265843961425609e-02
GL_26 0 NS_26 NS_25 0 -2.5265843961425609e-02
GS_25_1 0 NS_25 NA_1 0 4.4004921040099176e-02
*
* Complex pair n. 27/28
CS_27 NS_27 0 9.9999999999999998e-13
CS_28 NS_28 0 9.9999999999999998e-13
RS_27 NS_27 0 1.6951639079934257e+03
RS_28 NS_28 0 1.6951639079934257e+03
GL_27 0 NS_27 NS_28 0 2.3972084214818105e-02
GL_28 0 NS_28 NS_27 0 -2.3972084214818105e-02
GS_27_1 0 NS_27 NA_1 0 4.4004921040099176e-02
*
* Complex pair n. 29/30
CS_29 NS_29 0 9.9999999999999998e-13
CS_30 NS_30 0 9.9999999999999998e-13
RS_29 NS_29 0 1.9827459345435975e+03
RS_30 NS_30 0 1.9827459345435975e+03
GL_29 0 NS_29 NS_30 0 2.2010638843335793e-02
GL_30 0 NS_30 NS_29 0 -2.2010638843335793e-02
GS_29_1 0 NS_29 NA_1 0 4.4004921040099176e-02
*
* Complex pair n. 31/32
CS_31 NS_31 0 9.9999999999999998e-13
CS_32 NS_32 0 9.9999999999999998e-13
RS_31 NS_31 0 1.3486863662474116e+03
RS_32 NS_32 0 1.3486863662474116e+03
GL_31 0 NS_31 NS_32 0 2.0984510216869819e-02
GL_32 0 NS_32 NS_31 0 -2.0984510216869819e-02
GS_31_1 0 NS_31 NA_1 0 4.4004921040099176e-02
*
* Complex pair n. 33/34
CS_33 NS_33 0 9.9999999999999998e-13
CS_34 NS_34 0 9.9999999999999998e-13
RS_33 NS_33 0 1.7459695373483485e+03
RS_34 NS_34 0 1.7459695373483485e+03
GL_33 0 NS_33 NS_34 0 1.8640133315787094e-02
GL_34 0 NS_34 NS_33 0 -1.8640133315787094e-02
GS_33_1 0 NS_33 NA_1 0 4.4004921040099176e-02
*
* Complex pair n. 35/36
CS_35 NS_35 0 9.9999999999999998e-13
CS_36 NS_36 0 9.9999999999999998e-13
RS_35 NS_35 0 2.7352279757291626e+03
RS_36 NS_36 0 2.7352279757291626e+03
GL_35 0 NS_35 NS_36 0 1.6994271029263260e-02
GL_36 0 NS_36 NS_35 0 -1.6994271029263260e-02
GS_35_1 0 NS_35 NA_1 0 4.4004921040099176e-02
*
* Complex pair n. 37/38
CS_37 NS_37 0 9.9999999999999998e-13
CS_38 NS_38 0 9.9999999999999998e-13
RS_37 NS_37 0 1.0340791267054317e+03
RS_38 NS_38 0 1.0340791267054317e+03
GL_37 0 NS_37 NS_38 0 1.5527016953895832e-02
GL_38 0 NS_38 NS_37 0 -1.5527016953895832e-02
GS_37_1 0 NS_37 NA_1 0 4.4004921040099176e-02
*
* Complex pair n. 39/40
CS_39 NS_39 0 9.9999999999999998e-13
CS_40 NS_40 0 9.9999999999999998e-13
RS_39 NS_39 0 2.2269110879263071e+03
RS_40 NS_40 0 2.2269110879263071e+03
GL_39 0 NS_39 NS_40 0 1.4796176016169012e-02
GL_40 0 NS_40 NS_39 0 -1.4796176016169012e-02
GS_39_1 0 NS_39 NA_1 0 4.4004921040099176e-02
*
* Complex pair n. 41/42
CS_41 NS_41 0 9.9999999999999998e-13
CS_42 NS_42 0 9.9999999999999998e-13
RS_41 NS_41 0 2.4225116638213885e+03
RS_42 NS_42 0 2.4225116638213885e+03
GL_41 0 NS_41 NS_42 0 1.1935821677468598e-02
GL_42 0 NS_42 NS_41 0 -1.1935821677468598e-02
GS_41_1 0 NS_41 NA_1 0 4.4004921040099176e-02
*
* Complex pair n. 43/44
CS_43 NS_43 0 9.9999999999999998e-13
CS_44 NS_44 0 9.9999999999999998e-13
RS_43 NS_43 0 3.7963313360059556e+03
RS_44 NS_44 0 3.7963313360059556e+03
GL_43 0 NS_43 NS_44 0 1.0692904116553917e-02
GL_44 0 NS_44 NS_43 0 -1.0692904116553917e-02
GS_43_1 0 NS_43 NA_1 0 4.4004921040099176e-02
*
* Complex pair n. 45/46
CS_45 NS_45 0 9.9999999999999998e-13
CS_46 NS_46 0 9.9999999999999998e-13
RS_45 NS_45 0 3.0527730389950416e+03
RS_46 NS_46 0 3.0527730389950411e+03
GL_45 0 NS_45 NS_46 0 9.0482041562484714e-03
GL_46 0 NS_46 NS_45 0 -9.0482041562484714e-03
GS_45_1 0 NS_45 NA_1 0 4.4004921040099176e-02
*
* Complex pair n. 47/48
CS_47 NS_47 0 9.9999999999999998e-13
CS_48 NS_48 0 9.9999999999999998e-13
RS_47 NS_47 0 3.6225123030792493e+03
RS_48 NS_48 0 3.6225123030792488e+03
GL_47 0 NS_47 NS_48 0 6.0712920372275291e-03
GL_48 0 NS_48 NS_47 0 -6.0712920372275291e-03
GS_47_1 0 NS_47 NA_1 0 4.4004921040099176e-02
*
* Complex pair n. 49/50
CS_49 NS_49 0 9.9999999999999998e-13
CS_50 NS_50 0 9.9999999999999998e-13
RS_49 NS_49 0 4.5657551871681244e+03
RS_50 NS_50 0 4.5657551871681244e+03
GL_49 0 NS_49 NS_50 0 5.6442675130025594e-03
GL_50 0 NS_50 NS_49 0 -5.6442675130025594e-03
GS_49_1 0 NS_49 NA_1 0 4.4004921040099176e-02
*
* Complex pair n. 51/52
CS_51 NS_51 0 9.9999999999999998e-13
CS_52 NS_52 0 9.9999999999999998e-13
RS_51 NS_51 0 7.0832427939187919e+03
RS_52 NS_52 0 7.0832427939187928e+03
GL_51 0 NS_51 NS_52 0 3.8551722329818487e-03
GL_52 0 NS_52 NS_51 0 -3.8551722329818487e-03
GS_51_1 0 NS_51 NA_1 0 4.4004921040099176e-02
*
* Complex pair n. 53/54
CS_53 NS_53 0 9.9999999999999998e-13
CS_54 NS_54 0 9.9999999999999998e-13
RS_53 NS_53 0 9.1543447711539156e+03
RS_54 NS_54 0 9.1543447711539156e+03
GL_53 0 NS_53 NS_54 0 3.1164107011310642e-03
GL_54 0 NS_54 NS_53 0 -3.1164107011310642e-03
GS_53_1 0 NS_53 NA_1 0 4.4004921040099176e-02
*
* Complex pair n. 55/56
CS_55 NS_55 0 9.9999999999999998e-13
CS_56 NS_56 0 9.9999999999999998e-13
RS_55 NS_55 0 2.0997104441094954e+04
RS_56 NS_56 0 2.0997104441094954e+04
GL_55 0 NS_55 NS_56 0 2.6764554843551884e-04
GL_56 0 NS_56 NS_55 0 -2.6764554843551884e-04
GS_55_1 0 NS_55 NA_1 0 4.4004921040099176e-02
*
* Complex pair n. 57/58
CS_57 NS_57 0 9.9999999999999998e-13
CS_58 NS_58 0 9.9999999999999998e-13
RS_57 NS_57 0 3.1656247896772107e+04
RS_58 NS_58 0 3.1656247896772111e+04
GL_57 0 NS_57 NS_58 0 2.2734827711714070e-04
GL_58 0 NS_58 NS_57 0 -2.2734827711714070e-04
GS_57_1 0 NS_57 NA_1 0 4.4004921040099176e-02
*
* Complex pair n. 59/60
CS_59 NS_59 0 9.9999999999999998e-13
CS_60 NS_60 0 9.9999999999999998e-13
RS_59 NS_59 0 2.6170898508622675e+04
RS_60 NS_60 0 2.6170898508622675e+04
GL_59 0 NS_59 NS_60 0 1.0734708970066073e-04
GL_60 0 NS_60 NS_59 0 -1.0734708970066073e-04
GS_59_1 0 NS_59 NA_1 0 4.4004921040099176e-02
*
* Complex pair n. 61/62
CS_61 NS_61 0 9.9999999999999998e-13
CS_62 NS_62 0 9.9999999999999998e-13
RS_61 NS_61 0 1.9415833195494616e+05
RS_62 NS_62 0 1.9415833195494619e+05
GL_61 0 NS_61 NS_62 0 1.4366189855202119e-05
GL_62 0 NS_62 NS_61 0 -1.4366189855202119e-05
GS_61_1 0 NS_61 NA_1 0 4.4004921040099176e-02
*
* Real pole n. 63
CS_63 NS_63 0 9.9999999999999998e-13
RS_63 NS_63 0 2.6812382496167982e+02
GS_63_2 0 NS_63 NA_2 0 4.4004921040099176e-02
*
* Real pole n. 64
CS_64 NS_64 0 9.9999999999999998e-13
RS_64 NS_64 0 1.3994731188988526e+03
GS_64_2 0 NS_64 NA_2 0 4.4004921040099176e-02
*
* Real pole n. 65
CS_65 NS_65 0 9.9999999999999998e-13
RS_65 NS_65 0 2.2826790726153595e+03
GS_65_2 0 NS_65 NA_2 0 4.4004921040099176e-02
*
* Real pole n. 66
CS_66 NS_66 0 9.9999999999999998e-13
RS_66 NS_66 0 8.9038736282574646e+03
GS_66_2 0 NS_66 NA_2 0 4.4004921040099176e-02
*
* Real pole n. 67
CS_67 NS_67 0 9.9999999999999998e-13
RS_67 NS_67 0 8.1624030462346354e+05
GS_67_2 0 NS_67 NA_2 0 4.4004921040099176e-02
*
* Real pole n. 68
CS_68 NS_68 0 9.9999999999999998e-13
RS_68 NS_68 0 1.5686805607432274e+06
GS_68_2 0 NS_68 NA_2 0 4.4004921040099176e-02
*
* Real pole n. 69
CS_69 NS_69 0 9.9999999999999998e-13
RS_69 NS_69 0 7.4956827294422567e+08
GS_69_2 0 NS_69 NA_2 0 4.4004921040099176e-02
*
* Real pole n. 70
CS_70 NS_70 0 9.9999999999999998e-13
RS_70 NS_70 0 2.9819117004006445e+08
GS_70_2 0 NS_70 NA_2 0 4.4004921040099176e-02
*
* Real pole n. 71
CS_71 NS_71 0 9.9999999999999998e-13
RS_71 NS_71 0 5.8398553078453373e+06
GS_71_2 0 NS_71 NA_2 0 4.4004921040099176e-02
*
* Real pole n. 72
CS_72 NS_72 0 9.9999999999999998e-13
RS_72 NS_72 0 2.4450573444296578e+06
GS_72_2 0 NS_72 NA_2 0 4.4004921040099176e-02
*
* Complex pair n. 73/74
CS_73 NS_73 0 9.9999999999999998e-13
CS_74 NS_74 0 9.9999999999999998e-13
RS_73 NS_73 0 5.8489347765199994e+01
RS_74 NS_74 0 5.8489347765199994e+01
GL_73 0 NS_73 NS_74 0 3.0506948724049354e-02
GL_74 0 NS_74 NS_73 0 -3.0506948724049354e-02
GS_73_2 0 NS_73 NA_2 0 4.4004921040099176e-02
*
* Complex pair n. 75/76
CS_75 NS_75 0 9.9999999999999998e-13
CS_76 NS_76 0 9.9999999999999998e-13
RS_75 NS_75 0 7.9970336946000464e+02
RS_76 NS_76 0 7.9970336946000452e+02
GL_75 0 NS_75 NS_76 0 3.1496579383007282e-02
GL_76 0 NS_76 NS_75 0 -3.1496579383007282e-02
GS_75_2 0 NS_75 NA_2 0 4.4004921040099176e-02
*
* Complex pair n. 77/78
CS_77 NS_77 0 9.9999999999999998e-13
CS_78 NS_78 0 9.9999999999999998e-13
RS_77 NS_77 0 1.8036406617964012e+03
RS_78 NS_78 0 1.8036406617964012e+03
GL_77 0 NS_77 NS_78 0 3.0333145406357103e-02
GL_78 0 NS_78 NS_77 0 -3.0333145406357103e-02
GS_77_2 0 NS_77 NA_2 0 4.4004921040099176e-02
*
* Complex pair n. 79/80
CS_79 NS_79 0 9.9999999999999998e-13
CS_80 NS_80 0 9.9999999999999998e-13
RS_79 NS_79 0 1.4319660708934398e+03
RS_80 NS_80 0 1.4319660708934400e+03
GL_79 0 NS_79 NS_80 0 2.9535265241571747e-02
GL_80 0 NS_80 NS_79 0 -2.9535265241571747e-02
GS_79_2 0 NS_79 NA_2 0 4.4004921040099176e-02
*
* Complex pair n. 81/82
CS_81 NS_81 0 9.9999999999999998e-13
CS_82 NS_82 0 9.9999999999999998e-13
RS_81 NS_81 0 1.4182072682574346e+03
RS_82 NS_82 0 1.4182072682574344e+03
GL_81 0 NS_81 NS_82 0 2.8637997504011751e-02
GL_82 0 NS_82 NS_81 0 -2.8637997504011751e-02
GS_81_2 0 NS_81 NA_2 0 4.4004921040099176e-02
*
* Complex pair n. 83/84
CS_83 NS_83 0 9.9999999999999998e-13
CS_84 NS_84 0 9.9999999999999998e-13
RS_83 NS_83 0 1.1280382663726675e+03
RS_84 NS_84 0 1.1280382663726675e+03
GL_83 0 NS_83 NS_84 0 2.7322429360434351e-02
GL_84 0 NS_84 NS_83 0 -2.7322429360434351e-02
GS_83_2 0 NS_83 NA_2 0 4.4004921040099176e-02
*
* Complex pair n. 85/86
CS_85 NS_85 0 9.9999999999999998e-13
CS_86 NS_86 0 9.9999999999999998e-13
RS_85 NS_85 0 1.5126459944053822e+03
RS_86 NS_86 0 1.5126459944053822e+03
GL_85 0 NS_85 NS_86 0 2.5612783053065323e-02
GL_86 0 NS_86 NS_85 0 -2.5612783053065323e-02
GS_85_2 0 NS_85 NA_2 0 4.4004921040099176e-02
*
* Complex pair n. 87/88
CS_87 NS_87 0 9.9999999999999998e-13
CS_88 NS_88 0 9.9999999999999998e-13
RS_87 NS_87 0 1.5212465428239163e+03
RS_88 NS_88 0 1.5212465428239163e+03
GL_87 0 NS_87 NS_88 0 2.5265843961425609e-02
GL_88 0 NS_88 NS_87 0 -2.5265843961425609e-02
GS_87_2 0 NS_87 NA_2 0 4.4004921040099176e-02
*
* Complex pair n. 89/90
CS_89 NS_89 0 9.9999999999999998e-13
CS_90 NS_90 0 9.9999999999999998e-13
RS_89 NS_89 0 1.6951639079934257e+03
RS_90 NS_90 0 1.6951639079934257e+03
GL_89 0 NS_89 NS_90 0 2.3972084214818105e-02
GL_90 0 NS_90 NS_89 0 -2.3972084214818105e-02
GS_89_2 0 NS_89 NA_2 0 4.4004921040099176e-02
*
* Complex pair n. 91/92
CS_91 NS_91 0 9.9999999999999998e-13
CS_92 NS_92 0 9.9999999999999998e-13
RS_91 NS_91 0 1.9827459345435975e+03
RS_92 NS_92 0 1.9827459345435975e+03
GL_91 0 NS_91 NS_92 0 2.2010638843335793e-02
GL_92 0 NS_92 NS_91 0 -2.2010638843335793e-02
GS_91_2 0 NS_91 NA_2 0 4.4004921040099176e-02
*
* Complex pair n. 93/94
CS_93 NS_93 0 9.9999999999999998e-13
CS_94 NS_94 0 9.9999999999999998e-13
RS_93 NS_93 0 1.3486863662474116e+03
RS_94 NS_94 0 1.3486863662474116e+03
GL_93 0 NS_93 NS_94 0 2.0984510216869819e-02
GL_94 0 NS_94 NS_93 0 -2.0984510216869819e-02
GS_93_2 0 NS_93 NA_2 0 4.4004921040099176e-02
*
* Complex pair n. 95/96
CS_95 NS_95 0 9.9999999999999998e-13
CS_96 NS_96 0 9.9999999999999998e-13
RS_95 NS_95 0 1.7459695373483485e+03
RS_96 NS_96 0 1.7459695373483485e+03
GL_95 0 NS_95 NS_96 0 1.8640133315787094e-02
GL_96 0 NS_96 NS_95 0 -1.8640133315787094e-02
GS_95_2 0 NS_95 NA_2 0 4.4004921040099176e-02
*
* Complex pair n. 97/98
CS_97 NS_97 0 9.9999999999999998e-13
CS_98 NS_98 0 9.9999999999999998e-13
RS_97 NS_97 0 2.7352279757291626e+03
RS_98 NS_98 0 2.7352279757291626e+03
GL_97 0 NS_97 NS_98 0 1.6994271029263260e-02
GL_98 0 NS_98 NS_97 0 -1.6994271029263260e-02
GS_97_2 0 NS_97 NA_2 0 4.4004921040099176e-02
*
* Complex pair n. 99/100
CS_99 NS_99 0 9.9999999999999998e-13
CS_100 NS_100 0 9.9999999999999998e-13
RS_99 NS_99 0 1.0340791267054317e+03
RS_100 NS_100 0 1.0340791267054317e+03
GL_99 0 NS_99 NS_100 0 1.5527016953895832e-02
GL_100 0 NS_100 NS_99 0 -1.5527016953895832e-02
GS_99_2 0 NS_99 NA_2 0 4.4004921040099176e-02
*
* Complex pair n. 101/102
CS_101 NS_101 0 9.9999999999999998e-13
CS_102 NS_102 0 9.9999999999999998e-13
RS_101 NS_101 0 2.2269110879263071e+03
RS_102 NS_102 0 2.2269110879263071e+03
GL_101 0 NS_101 NS_102 0 1.4796176016169012e-02
GL_102 0 NS_102 NS_101 0 -1.4796176016169012e-02
GS_101_2 0 NS_101 NA_2 0 4.4004921040099176e-02
*
* Complex pair n. 103/104
CS_103 NS_103 0 9.9999999999999998e-13
CS_104 NS_104 0 9.9999999999999998e-13
RS_103 NS_103 0 2.4225116638213885e+03
RS_104 NS_104 0 2.4225116638213885e+03
GL_103 0 NS_103 NS_104 0 1.1935821677468598e-02
GL_104 0 NS_104 NS_103 0 -1.1935821677468598e-02
GS_103_2 0 NS_103 NA_2 0 4.4004921040099176e-02
*
* Complex pair n. 105/106
CS_105 NS_105 0 9.9999999999999998e-13
CS_106 NS_106 0 9.9999999999999998e-13
RS_105 NS_105 0 3.7963313360059556e+03
RS_106 NS_106 0 3.7963313360059556e+03
GL_105 0 NS_105 NS_106 0 1.0692904116553917e-02
GL_106 0 NS_106 NS_105 0 -1.0692904116553917e-02
GS_105_2 0 NS_105 NA_2 0 4.4004921040099176e-02
*
* Complex pair n. 107/108
CS_107 NS_107 0 9.9999999999999998e-13
CS_108 NS_108 0 9.9999999999999998e-13
RS_107 NS_107 0 3.0527730389950416e+03
RS_108 NS_108 0 3.0527730389950411e+03
GL_107 0 NS_107 NS_108 0 9.0482041562484714e-03
GL_108 0 NS_108 NS_107 0 -9.0482041562484714e-03
GS_107_2 0 NS_107 NA_2 0 4.4004921040099176e-02
*
* Complex pair n. 109/110
CS_109 NS_109 0 9.9999999999999998e-13
CS_110 NS_110 0 9.9999999999999998e-13
RS_109 NS_109 0 3.6225123030792493e+03
RS_110 NS_110 0 3.6225123030792488e+03
GL_109 0 NS_109 NS_110 0 6.0712920372275291e-03
GL_110 0 NS_110 NS_109 0 -6.0712920372275291e-03
GS_109_2 0 NS_109 NA_2 0 4.4004921040099176e-02
*
* Complex pair n. 111/112
CS_111 NS_111 0 9.9999999999999998e-13
CS_112 NS_112 0 9.9999999999999998e-13
RS_111 NS_111 0 4.5657551871681244e+03
RS_112 NS_112 0 4.5657551871681244e+03
GL_111 0 NS_111 NS_112 0 5.6442675130025594e-03
GL_112 0 NS_112 NS_111 0 -5.6442675130025594e-03
GS_111_2 0 NS_111 NA_2 0 4.4004921040099176e-02
*
* Complex pair n. 113/114
CS_113 NS_113 0 9.9999999999999998e-13
CS_114 NS_114 0 9.9999999999999998e-13
RS_113 NS_113 0 7.0832427939187919e+03
RS_114 NS_114 0 7.0832427939187928e+03
GL_113 0 NS_113 NS_114 0 3.8551722329818487e-03
GL_114 0 NS_114 NS_113 0 -3.8551722329818487e-03
GS_113_2 0 NS_113 NA_2 0 4.4004921040099176e-02
*
* Complex pair n. 115/116
CS_115 NS_115 0 9.9999999999999998e-13
CS_116 NS_116 0 9.9999999999999998e-13
RS_115 NS_115 0 9.1543447711539156e+03
RS_116 NS_116 0 9.1543447711539156e+03
GL_115 0 NS_115 NS_116 0 3.1164107011310642e-03
GL_116 0 NS_116 NS_115 0 -3.1164107011310642e-03
GS_115_2 0 NS_115 NA_2 0 4.4004921040099176e-02
*
* Complex pair n. 117/118
CS_117 NS_117 0 9.9999999999999998e-13
CS_118 NS_118 0 9.9999999999999998e-13
RS_117 NS_117 0 2.0997104441094954e+04
RS_118 NS_118 0 2.0997104441094954e+04
GL_117 0 NS_117 NS_118 0 2.6764554843551884e-04
GL_118 0 NS_118 NS_117 0 -2.6764554843551884e-04
GS_117_2 0 NS_117 NA_2 0 4.4004921040099176e-02
*
* Complex pair n. 119/120
CS_119 NS_119 0 9.9999999999999998e-13
CS_120 NS_120 0 9.9999999999999998e-13
RS_119 NS_119 0 3.1656247896772107e+04
RS_120 NS_120 0 3.1656247896772111e+04
GL_119 0 NS_119 NS_120 0 2.2734827711714070e-04
GL_120 0 NS_120 NS_119 0 -2.2734827711714070e-04
GS_119_2 0 NS_119 NA_2 0 4.4004921040099176e-02
*
* Complex pair n. 121/122
CS_121 NS_121 0 9.9999999999999998e-13
CS_122 NS_122 0 9.9999999999999998e-13
RS_121 NS_121 0 2.6170898508622675e+04
RS_122 NS_122 0 2.6170898508622675e+04
GL_121 0 NS_121 NS_122 0 1.0734708970066073e-04
GL_122 0 NS_122 NS_121 0 -1.0734708970066073e-04
GS_121_2 0 NS_121 NA_2 0 4.4004921040099176e-02
*
* Complex pair n. 123/124
CS_123 NS_123 0 9.9999999999999998e-13
CS_124 NS_124 0 9.9999999999999998e-13
RS_123 NS_123 0 1.9415833195494616e+05
RS_124 NS_124 0 1.9415833195494619e+05
GL_123 0 NS_123 NS_124 0 1.4366189855202119e-05
GL_124 0 NS_124 NS_123 0 -1.4366189855202119e-05
GS_123_2 0 NS_123 NA_2 0 4.4004921040099176e-02
*
******************************

.ends
*******************
* End of subcircuit
*******************
